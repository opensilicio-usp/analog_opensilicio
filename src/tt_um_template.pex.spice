* PEX produced on Fri May 15 11:11:51 PM CEST 2026 using /foss/tools/sak/sak-pex.sh with m=3 and s=1
* NGSPICE file created from tt_um_template.ext - technology: sky130A

.subckt tt_um_template
X0 a_6537_25279.t2 a_6497_25339# w_6348_25095.t13 w_6348_25095.t12 sky130_fd_pr__pfet_01v8 ad=1 pd=4.5 as=1 ps=4.5 w=4 l=0.35
X1 a_12100_25279.t5 a_11994_25339# w_11843_25095.t5 w_11843_25095.t4 sky130_fd_pr__pfet_01v8 ad=1 pd=4.5 as=1 ps=4.5 w=4 l=0.35
X2 w_6348_25095.t3 a_6497_25339# a_6537_25279.t5 w_6348_25095.t2 sky130_fd_pr__pfet_01v8 ad=1 pd=4.5 as=1 ps=4.5 w=4 l=0.35
X3 a_12100_25279.t4 a_11994_25339# w_11843_25095.t9 w_11843_25095.t8 sky130_fd_pr__pfet_01v8 ad=1 pd=4.5 as=1 ps=4.5 w=4 l=0.35
X4 a_6537_25279.t8 a_6525_23427# w_6290_22150.t3 w_6290_22150.t2 sky130_fd_pr__nfet_01v8_lvt ad=0.3 pd=2.6 as=0.3 ps=2.6 w=1 l=0.15
X5 w_6348_25095.t7 a_6497_25339# a_6537_25279.t1 w_6348_25095.t6 sky130_fd_pr__pfet_01v8 ad=1 pd=4.5 as=1 ps=4.5 w=4 l=0.35
X6 a_12100_25279.t3 a_11994_25339# w_11843_25095.t13 w_11843_25095.t12 sky130_fd_pr__pfet_01v8 ad=1 pd=4.5 as=1 ps=4.5 w=4 l=0.35
X7 w_11843_25095.t3 a_11994_25339# a_12100_25279.t8 w_11843_25095.t2 sky130_fd_pr__pfet_01v8 ad=1 pd=4.5 as=1 ps=4.5 w=4 l=0.35
X8 a_6537_25279.t4 a_6497_25339# w_6348_25095.t1 w_6348_25095.t0 sky130_fd_pr__pfet_01v8 ad=1.2 pd=8.6 as=1 ps=4.5 w=4 l=0.35
X9 w_11843_25095.t7 a_11994_25339# a_12100_25279.t2 w_11843_25095.t6 sky130_fd_pr__pfet_01v8 ad=1 pd=4.5 as=1 ps=4.5 w=4 l=0.35
X10 w_6348_25095.t11 a_6497_25339# a_6537_25279.t0 w_6348_25095.t10 sky130_fd_pr__pfet_01v8 ad=1 pd=4.5 as=1 ps=4.5 w=4 l=0.35
X11 a_12100_25279.t6 a_11994_25339# w_11843_25095.t1 w_11843_25095.t0 sky130_fd_pr__pfet_01v8 ad=1.2 pd=8.6 as=1 ps=4.5 w=4 l=0.35
X12 w_6348_25095.t15 a_6497_25339# a_6537_25279.t6 w_6348_25095.t14 sky130_fd_pr__pfet_01v8 ad=1 pd=4.5 as=1.2 ps=8.6 w=4 l=0.35
X13 a_12100_25279.t0 a_12566_23415# w_6290_22150.t1 w_6290_22150.t0 sky130_fd_pr__nfet_01v8_lvt ad=0.3 pd=2.6 as=0.3 ps=2.6 w=1 l=0.15
X14 c1_8428_29658# m3_8388_29618.t0 sky130_fd_pr__cap_mim_m3_1 l=32 w=32
X15 a_6537_25279.t7 a_6497_25339# w_6348_25095.t5 w_6348_25095.t4 sky130_fd_pr__pfet_01v8 ad=1 pd=4.5 as=1 ps=4.5 w=4 l=0.35
X16 w_11843_25095.t11 a_11994_25339# a_12100_25279.t7 w_11843_25095.t10 sky130_fd_pr__pfet_01v8 ad=1 pd=4.5 as=1 ps=4.5 w=4 l=0.35
X17 a_6537_25279.t3 a_6497_25339# w_6348_25095.t9 w_6348_25095.t8 sky130_fd_pr__pfet_01v8 ad=1 pd=4.5 as=1 ps=4.5 w=4 l=0.35
X18 w_11843_25095.t15 a_11994_25339# a_12100_25279.t1 w_11843_25095.t14 sky130_fd_pr__pfet_01v8 ad=1 pd=4.5 as=1.2 ps=8.6 w=4 l=0.35
R0 m3_8388_29618.n0 m3_8388_29618.t0 0.024
R1 a_12100_25279.t0 a_12100_25279.n228 135.685
R2 a_12100_25279.n228 a_12100_25279.n182 0.46027
R3 a_12100_25279.n182 a_12100_25279.n136 0.489006
R4 a_12100_25279.n136 a_12100_25279.n90 0.489006
R5 a_12100_25279.n185 a_12100_25279.n184 4.5005
R6 a_12100_25279.n186 a_12100_25279.n187 4.5005
R7 a_12100_25279.n188 a_12100_25279.n189 4.5005
R8 a_12100_25279.n190 a_12100_25279.n191 4.5005
R9 a_12100_25279.n192 a_12100_25279.n193 4.5005
R10 a_12100_25279.n194 a_12100_25279.n195 4.5005
R11 a_12100_25279.n196 a_12100_25279.n197 4.5005
R12 a_12100_25279.n198 a_12100_25279.n199 4.5005
R13 a_12100_25279.n200 a_12100_25279.n201 4.5005
R14 a_12100_25279.n202 a_12100_25279.n203 4.5005
R15 a_12100_25279.n183 a_12100_25279.n204 0.0618108
R16 a_12100_25279.n228 a_12100_25279.n185 0.191906
R17 a_12100_25279.n185 a_12100_25279.n187 0.1255
R18 a_12100_25279.n187 a_12100_25279.n189 0.1255
R19 a_12100_25279.n189 a_12100_25279.n191 0.1255
R20 a_12100_25279.n191 a_12100_25279.n193 0.1255
R21 a_12100_25279.n193 a_12100_25279.n195 0.1255
R22 a_12100_25279.n195 a_12100_25279.n197 0.1255
R23 a_12100_25279.n197 a_12100_25279.n199 0.1255
R24 a_12100_25279.n199 a_12100_25279.n201 0.1255
R25 a_12100_25279.n201 a_12100_25279.n203 0.1255
R26 a_12100_25279.n203 a_12100_25279.n183 2.376
R27 a_12100_25279.n204 a_12100_25279.n205 9.3005
R28 a_12100_25279.n207 a_12100_25279.n206 9.3005
R29 a_12100_25279.n209 a_12100_25279.n208 9.3005
R30 a_12100_25279.n211 a_12100_25279.n210 9.3005
R31 a_12100_25279.n213 a_12100_25279.n212 9.3005
R32 a_12100_25279.n215 a_12100_25279.n214 9.3005
R33 a_12100_25279.n217 a_12100_25279.n216 9.3005
R34 a_12100_25279.n219 a_12100_25279.n218 9.3005
R35 a_12100_25279.n186 a_12100_25279.n220 9.3005
R36 a_12100_25279.n184 a_12100_25279.n221 9.31613
R37 a_12100_25279.n184 a_12100_25279.n186 0.1255
R38 a_12100_25279.n186 a_12100_25279.n188 0.1255
R39 a_12100_25279.n219 a_12100_25279.n188 0.016125
R40 a_12100_25279.n190 a_12100_25279.n219 0.109875
R41 a_12100_25279.n217 a_12100_25279.n190 0.03175
R42 a_12100_25279.n192 a_12100_25279.n217 0.09425
R43 a_12100_25279.n215 a_12100_25279.n192 0.047375
R44 a_12100_25279.n194 a_12100_25279.n215 0.078625
R45 a_12100_25279.n213 a_12100_25279.n194 0.063
R46 a_12100_25279.n196 a_12100_25279.n213 0.063
R47 a_12100_25279.n211 a_12100_25279.n196 0.078625
R48 a_12100_25279.n198 a_12100_25279.n211 0.047375
R49 a_12100_25279.n209 a_12100_25279.n198 0.09425
R50 a_12100_25279.n200 a_12100_25279.n209 0.03175
R51 a_12100_25279.n207 a_12100_25279.n200 0.109875
R52 a_12100_25279.n202 a_12100_25279.n207 0.016125
R53 a_12100_25279.n204 a_12100_25279.n202 0.1255
R54 a_12100_25279.n226 a_12100_25279.n227 285.877
R55 a_12100_25279.n205 a_12100_25279.n226 13.2471
R56 a_12100_25279.n227 a_12100_25279.n225 285.877
R57 a_12100_25279.n225 a_12100_25279.n208 13.2471
R58 a_12100_25279.n227 a_12100_25279.n224 285.877
R59 a_12100_25279.n224 a_12100_25279.n212 13.2471
R60 a_12100_25279.n227 a_12100_25279.n223 285.877
R61 a_12100_25279.n223 a_12100_25279.n216 13.2471
R62 a_12100_25279.n227 a_12100_25279.n222 285.877
R63 a_12100_25279.n222 a_12100_25279.n220 13.2471
R64 a_12100_25279.n227 a_12100_25279.n221 585
R65 a_12100_25279.n221 a_12100_25279.n220 27.1064
R66 a_12100_25279.n218 a_12100_25279.n222 13.2471
R67 a_12100_25279.n218 a_12100_25279.n216 27.1064
R68 a_12100_25279.n214 a_12100_25279.n223 13.2471
R69 a_12100_25279.n214 a_12100_25279.n212 27.1064
R70 a_12100_25279.n210 a_12100_25279.n224 13.2471
R71 a_12100_25279.n210 a_12100_25279.n208 27.1064
R72 a_12100_25279.n206 a_12100_25279.n225 13.2471
R73 a_12100_25279.n206 a_12100_25279.n205 27.1064
R74 a_12100_25279.n226 a_12100_25279.n183 22.6257
R75 a_12100_25279.n227 a_12100_25279.t1 7.388
R76 a_12100_25279.n139 a_12100_25279.n138 4.5005
R77 a_12100_25279.n141 a_12100_25279.n140 4.5005
R78 a_12100_25279.n142 a_12100_25279.n143 4.5005
R79 a_12100_25279.n144 a_12100_25279.n145 4.5005
R80 a_12100_25279.n146 a_12100_25279.n147 4.5005
R81 a_12100_25279.n148 a_12100_25279.n149 4.5005
R82 a_12100_25279.n150 a_12100_25279.n151 4.5005
R83 a_12100_25279.n152 a_12100_25279.n153 4.5005
R84 a_12100_25279.n154 a_12100_25279.n155 4.5005
R85 a_12100_25279.n156 a_12100_25279.n157 4.5005
R86 a_12100_25279.n137 a_12100_25279.n158 0.0618108
R87 a_12100_25279.n182 a_12100_25279.n139 0.191906
R88 a_12100_25279.n139 a_12100_25279.n141 0.1255
R89 a_12100_25279.n141 a_12100_25279.n143 0.1255
R90 a_12100_25279.n143 a_12100_25279.n145 0.1255
R91 a_12100_25279.n145 a_12100_25279.n147 0.1255
R92 a_12100_25279.n147 a_12100_25279.n149 0.1255
R93 a_12100_25279.n149 a_12100_25279.n151 0.1255
R94 a_12100_25279.n151 a_12100_25279.n153 0.1255
R95 a_12100_25279.n153 a_12100_25279.n155 0.1255
R96 a_12100_25279.n155 a_12100_25279.n157 0.1255
R97 a_12100_25279.n157 a_12100_25279.n137 2.376
R98 a_12100_25279.n158 a_12100_25279.n159 9.3005
R99 a_12100_25279.n161 a_12100_25279.n160 9.3005
R100 a_12100_25279.n163 a_12100_25279.n162 9.3005
R101 a_12100_25279.n165 a_12100_25279.n164 9.3005
R102 a_12100_25279.n167 a_12100_25279.n166 9.3005
R103 a_12100_25279.n169 a_12100_25279.n168 9.3005
R104 a_12100_25279.n171 a_12100_25279.n170 9.3005
R105 a_12100_25279.n173 a_12100_25279.n172 9.3005
R106 a_12100_25279.n140 a_12100_25279.n174 9.3005
R107 a_12100_25279.n138 a_12100_25279.n175 9.31613
R108 a_12100_25279.n138 a_12100_25279.n140 0.1255
R109 a_12100_25279.n140 a_12100_25279.n142 0.1255
R110 a_12100_25279.n173 a_12100_25279.n142 0.016125
R111 a_12100_25279.n144 a_12100_25279.n173 0.109875
R112 a_12100_25279.n171 a_12100_25279.n144 0.03175
R113 a_12100_25279.n146 a_12100_25279.n171 0.09425
R114 a_12100_25279.n169 a_12100_25279.n146 0.047375
R115 a_12100_25279.n148 a_12100_25279.n169 0.078625
R116 a_12100_25279.n167 a_12100_25279.n148 0.063
R117 a_12100_25279.n150 a_12100_25279.n167 0.063
R118 a_12100_25279.n165 a_12100_25279.n150 0.078625
R119 a_12100_25279.n152 a_12100_25279.n165 0.047375
R120 a_12100_25279.n163 a_12100_25279.n152 0.09425
R121 a_12100_25279.n154 a_12100_25279.n163 0.03175
R122 a_12100_25279.n161 a_12100_25279.n154 0.109875
R123 a_12100_25279.n156 a_12100_25279.n161 0.016125
R124 a_12100_25279.n158 a_12100_25279.n156 0.1255
R125 a_12100_25279.n180 a_12100_25279.n181 285.877
R126 a_12100_25279.n159 a_12100_25279.n180 13.2471
R127 a_12100_25279.n181 a_12100_25279.n179 285.877
R128 a_12100_25279.n179 a_12100_25279.n162 13.2471
R129 a_12100_25279.n181 a_12100_25279.n178 285.877
R130 a_12100_25279.n178 a_12100_25279.n166 13.2471
R131 a_12100_25279.n181 a_12100_25279.n177 285.877
R132 a_12100_25279.n177 a_12100_25279.n170 13.2471
R133 a_12100_25279.n181 a_12100_25279.n176 285.877
R134 a_12100_25279.n176 a_12100_25279.n174 13.2471
R135 a_12100_25279.n181 a_12100_25279.n175 585
R136 a_12100_25279.n175 a_12100_25279.n174 27.1064
R137 a_12100_25279.n172 a_12100_25279.n176 13.2471
R138 a_12100_25279.n172 a_12100_25279.n170 27.1064
R139 a_12100_25279.n168 a_12100_25279.n177 13.2471
R140 a_12100_25279.n168 a_12100_25279.n166 27.1064
R141 a_12100_25279.n164 a_12100_25279.n178 13.2471
R142 a_12100_25279.n164 a_12100_25279.n162 27.1064
R143 a_12100_25279.n160 a_12100_25279.n179 13.2471
R144 a_12100_25279.n160 a_12100_25279.n159 27.1064
R145 a_12100_25279.n180 a_12100_25279.n137 22.6257
R146 a_12100_25279.n181 a_12100_25279.t3 12.313
R147 a_12100_25279.n181 a_12100_25279.t7 12.313
R148 a_12100_25279.n93 a_12100_25279.n92 4.5005
R149 a_12100_25279.n95 a_12100_25279.n94 4.5005
R150 a_12100_25279.n96 a_12100_25279.n97 4.5005
R151 a_12100_25279.n98 a_12100_25279.n99 4.5005
R152 a_12100_25279.n100 a_12100_25279.n101 4.5005
R153 a_12100_25279.n102 a_12100_25279.n103 4.5005
R154 a_12100_25279.n104 a_12100_25279.n105 4.5005
R155 a_12100_25279.n106 a_12100_25279.n107 4.5005
R156 a_12100_25279.n108 a_12100_25279.n109 4.5005
R157 a_12100_25279.n110 a_12100_25279.n111 4.5005
R158 a_12100_25279.n91 a_12100_25279.n112 0.0618108
R159 a_12100_25279.n136 a_12100_25279.n93 0.191906
R160 a_12100_25279.n93 a_12100_25279.n95 0.1255
R161 a_12100_25279.n95 a_12100_25279.n97 0.1255
R162 a_12100_25279.n97 a_12100_25279.n99 0.1255
R163 a_12100_25279.n99 a_12100_25279.n101 0.1255
R164 a_12100_25279.n101 a_12100_25279.n103 0.1255
R165 a_12100_25279.n103 a_12100_25279.n105 0.1255
R166 a_12100_25279.n105 a_12100_25279.n107 0.1255
R167 a_12100_25279.n107 a_12100_25279.n109 0.1255
R168 a_12100_25279.n109 a_12100_25279.n111 0.1255
R169 a_12100_25279.n111 a_12100_25279.n91 2.376
R170 a_12100_25279.n112 a_12100_25279.n113 9.3005
R171 a_12100_25279.n115 a_12100_25279.n114 9.3005
R172 a_12100_25279.n117 a_12100_25279.n116 9.3005
R173 a_12100_25279.n119 a_12100_25279.n118 9.3005
R174 a_12100_25279.n121 a_12100_25279.n120 9.3005
R175 a_12100_25279.n123 a_12100_25279.n122 9.3005
R176 a_12100_25279.n125 a_12100_25279.n124 9.3005
R177 a_12100_25279.n127 a_12100_25279.n126 9.3005
R178 a_12100_25279.n94 a_12100_25279.n128 9.3005
R179 a_12100_25279.n92 a_12100_25279.n129 9.31613
R180 a_12100_25279.n92 a_12100_25279.n94 0.1255
R181 a_12100_25279.n94 a_12100_25279.n96 0.1255
R182 a_12100_25279.n127 a_12100_25279.n96 0.016125
R183 a_12100_25279.n98 a_12100_25279.n127 0.109875
R184 a_12100_25279.n125 a_12100_25279.n98 0.03175
R185 a_12100_25279.n100 a_12100_25279.n125 0.09425
R186 a_12100_25279.n123 a_12100_25279.n100 0.047375
R187 a_12100_25279.n102 a_12100_25279.n123 0.078625
R188 a_12100_25279.n121 a_12100_25279.n102 0.063
R189 a_12100_25279.n104 a_12100_25279.n121 0.063
R190 a_12100_25279.n119 a_12100_25279.n104 0.078625
R191 a_12100_25279.n106 a_12100_25279.n119 0.047375
R192 a_12100_25279.n117 a_12100_25279.n106 0.09425
R193 a_12100_25279.n108 a_12100_25279.n117 0.03175
R194 a_12100_25279.n115 a_12100_25279.n108 0.109875
R195 a_12100_25279.n110 a_12100_25279.n115 0.016125
R196 a_12100_25279.n112 a_12100_25279.n110 0.1255
R197 a_12100_25279.n134 a_12100_25279.n135 285.877
R198 a_12100_25279.n113 a_12100_25279.n134 13.2471
R199 a_12100_25279.n135 a_12100_25279.n133 285.877
R200 a_12100_25279.n133 a_12100_25279.n116 13.2471
R201 a_12100_25279.n135 a_12100_25279.n132 285.877
R202 a_12100_25279.n132 a_12100_25279.n120 13.2471
R203 a_12100_25279.n135 a_12100_25279.n131 285.877
R204 a_12100_25279.n131 a_12100_25279.n124 13.2471
R205 a_12100_25279.n135 a_12100_25279.n130 285.877
R206 a_12100_25279.n130 a_12100_25279.n128 13.2471
R207 a_12100_25279.n135 a_12100_25279.n129 585
R208 a_12100_25279.n129 a_12100_25279.n128 27.1064
R209 a_12100_25279.n126 a_12100_25279.n130 13.2471
R210 a_12100_25279.n126 a_12100_25279.n124 27.1064
R211 a_12100_25279.n122 a_12100_25279.n131 13.2471
R212 a_12100_25279.n122 a_12100_25279.n120 27.1064
R213 a_12100_25279.n118 a_12100_25279.n132 13.2471
R214 a_12100_25279.n118 a_12100_25279.n116 27.1064
R215 a_12100_25279.n114 a_12100_25279.n133 13.2471
R216 a_12100_25279.n114 a_12100_25279.n113 27.1064
R217 a_12100_25279.n134 a_12100_25279.n91 22.6257
R218 a_12100_25279.n135 a_12100_25279.t4 12.313
R219 a_12100_25279.n135 a_12100_25279.t2 12.313
R220 a_12100_25279.n47 a_12100_25279.n46 4.5005
R221 a_12100_25279.n48 a_12100_25279.n49 4.5005
R222 a_12100_25279.n50 a_12100_25279.n51 4.5005
R223 a_12100_25279.n52 a_12100_25279.n53 4.5005
R224 a_12100_25279.n54 a_12100_25279.n55 4.5005
R225 a_12100_25279.n56 a_12100_25279.n57 4.5005
R226 a_12100_25279.n58 a_12100_25279.n59 4.5005
R227 a_12100_25279.n60 a_12100_25279.n61 4.5005
R228 a_12100_25279.n62 a_12100_25279.n63 4.5005
R229 a_12100_25279.n64 a_12100_25279.n65 4.5005
R230 a_12100_25279.n45 a_12100_25279.n66 0.0618108
R231 a_12100_25279.n90 a_12100_25279.n47 0.191906
R232 a_12100_25279.n47 a_12100_25279.n49 0.1255
R233 a_12100_25279.n49 a_12100_25279.n51 0.1255
R234 a_12100_25279.n51 a_12100_25279.n53 0.1255
R235 a_12100_25279.n53 a_12100_25279.n55 0.1255
R236 a_12100_25279.n55 a_12100_25279.n57 0.1255
R237 a_12100_25279.n57 a_12100_25279.n59 0.1255
R238 a_12100_25279.n59 a_12100_25279.n61 0.1255
R239 a_12100_25279.n61 a_12100_25279.n63 0.1255
R240 a_12100_25279.n63 a_12100_25279.n65 0.1255
R241 a_12100_25279.n65 a_12100_25279.n45 2.376
R242 a_12100_25279.n66 a_12100_25279.n67 9.3005
R243 a_12100_25279.n69 a_12100_25279.n68 9.3005
R244 a_12100_25279.n71 a_12100_25279.n70 9.3005
R245 a_12100_25279.n73 a_12100_25279.n72 9.3005
R246 a_12100_25279.n75 a_12100_25279.n74 9.3005
R247 a_12100_25279.n77 a_12100_25279.n76 9.3005
R248 a_12100_25279.n79 a_12100_25279.n78 9.3005
R249 a_12100_25279.n81 a_12100_25279.n80 9.3005
R250 a_12100_25279.n48 a_12100_25279.n82 9.3005
R251 a_12100_25279.n46 a_12100_25279.n83 9.31613
R252 a_12100_25279.n46 a_12100_25279.n48 0.1255
R253 a_12100_25279.n48 a_12100_25279.n50 0.1255
R254 a_12100_25279.n81 a_12100_25279.n50 0.016125
R255 a_12100_25279.n52 a_12100_25279.n81 0.109875
R256 a_12100_25279.n79 a_12100_25279.n52 0.03175
R257 a_12100_25279.n54 a_12100_25279.n79 0.09425
R258 a_12100_25279.n77 a_12100_25279.n54 0.047375
R259 a_12100_25279.n56 a_12100_25279.n77 0.078625
R260 a_12100_25279.n75 a_12100_25279.n56 0.063
R261 a_12100_25279.n58 a_12100_25279.n75 0.063
R262 a_12100_25279.n73 a_12100_25279.n58 0.078625
R263 a_12100_25279.n60 a_12100_25279.n73 0.047375
R264 a_12100_25279.n71 a_12100_25279.n60 0.09425
R265 a_12100_25279.n62 a_12100_25279.n71 0.03175
R266 a_12100_25279.n69 a_12100_25279.n62 0.109875
R267 a_12100_25279.n64 a_12100_25279.n69 0.016125
R268 a_12100_25279.n66 a_12100_25279.n64 0.1255
R269 a_12100_25279.n88 a_12100_25279.n89 285.877
R270 a_12100_25279.n67 a_12100_25279.n88 13.2471
R271 a_12100_25279.n89 a_12100_25279.n87 285.877
R272 a_12100_25279.n87 a_12100_25279.n70 13.2471
R273 a_12100_25279.n89 a_12100_25279.n86 285.877
R274 a_12100_25279.n86 a_12100_25279.n74 13.2471
R275 a_12100_25279.n89 a_12100_25279.n85 285.877
R276 a_12100_25279.n85 a_12100_25279.n78 13.2471
R277 a_12100_25279.n89 a_12100_25279.n84 285.877
R278 a_12100_25279.n84 a_12100_25279.n82 13.2471
R279 a_12100_25279.n89 a_12100_25279.n83 585
R280 a_12100_25279.n83 a_12100_25279.n82 27.1064
R281 a_12100_25279.n80 a_12100_25279.n84 13.2471
R282 a_12100_25279.n80 a_12100_25279.n78 27.1064
R283 a_12100_25279.n76 a_12100_25279.n85 13.2471
R284 a_12100_25279.n76 a_12100_25279.n74 27.1064
R285 a_12100_25279.n72 a_12100_25279.n86 13.2471
R286 a_12100_25279.n72 a_12100_25279.n70 27.1064
R287 a_12100_25279.n68 a_12100_25279.n87 13.2471
R288 a_12100_25279.n68 a_12100_25279.n67 27.1064
R289 a_12100_25279.n88 a_12100_25279.n45 22.6257
R290 a_12100_25279.n89 a_12100_25279.t5 12.313
R291 a_12100_25279.n89 a_12100_25279.t8 12.313
R292 a_12100_25279.n1 a_12100_25279.n0 4.5005
R293 a_12100_25279.n2 a_12100_25279.n3 4.5005
R294 a_12100_25279.n4 a_12100_25279.n5 4.5005
R295 a_12100_25279.n6 a_12100_25279.n7 4.5005
R296 a_12100_25279.n8 a_12100_25279.n9 4.5005
R297 a_12100_25279.n10 a_12100_25279.n11 4.5005
R298 a_12100_25279.n12 a_12100_25279.n13 4.5005
R299 a_12100_25279.n14 a_12100_25279.n15 4.5005
R300 a_12100_25279.n16 a_12100_25279.n17 4.5005
R301 a_12100_25279.n18 a_12100_25279.n19 4.5005
R302 a_12100_25279.n44 a_12100_25279.n20 0.0618108
R303 a_12100_25279.n90 a_12100_25279.n1 0.653113
R304 a_12100_25279.n1 a_12100_25279.n3 0.1255
R305 a_12100_25279.n3 a_12100_25279.n5 0.1255
R306 a_12100_25279.n5 a_12100_25279.n7 0.1255
R307 a_12100_25279.n7 a_12100_25279.n9 0.1255
R308 a_12100_25279.n9 a_12100_25279.n11 0.1255
R309 a_12100_25279.n11 a_12100_25279.n13 0.1255
R310 a_12100_25279.n13 a_12100_25279.n15 0.1255
R311 a_12100_25279.n15 a_12100_25279.n17 0.1255
R312 a_12100_25279.n17 a_12100_25279.n19 0.1255
R313 a_12100_25279.n19 a_12100_25279.n44 2.376
R314 a_12100_25279.n2 a_12100_25279.n21 9.3005
R315 a_12100_25279.n23 a_12100_25279.n22 9.3005
R316 a_12100_25279.n25 a_12100_25279.n24 9.3005
R317 a_12100_25279.n27 a_12100_25279.n26 9.3005
R318 a_12100_25279.n29 a_12100_25279.n28 9.3005
R319 a_12100_25279.n31 a_12100_25279.n30 9.3005
R320 a_12100_25279.n33 a_12100_25279.n32 9.3005
R321 a_12100_25279.n35 a_12100_25279.n34 9.3005
R322 a_12100_25279.n20 a_12100_25279.n36 9.3005
R323 a_12100_25279.n0 a_12100_25279.n2 0.1255
R324 a_12100_25279.n2 a_12100_25279.n4 0.1255
R325 a_12100_25279.n23 a_12100_25279.n4 0.016125
R326 a_12100_25279.n6 a_12100_25279.n23 0.109875
R327 a_12100_25279.n25 a_12100_25279.n6 0.03175
R328 a_12100_25279.n8 a_12100_25279.n25 0.09425
R329 a_12100_25279.n27 a_12100_25279.n8 0.047375
R330 a_12100_25279.n10 a_12100_25279.n27 0.078625
R331 a_12100_25279.n29 a_12100_25279.n10 0.063
R332 a_12100_25279.n12 a_12100_25279.n29 0.063
R333 a_12100_25279.n31 a_12100_25279.n12 0.078625
R334 a_12100_25279.n14 a_12100_25279.n31 0.047375
R335 a_12100_25279.n33 a_12100_25279.n14 0.09425
R336 a_12100_25279.n16 a_12100_25279.n33 0.03175
R337 a_12100_25279.n35 a_12100_25279.n16 0.109875
R338 a_12100_25279.n18 a_12100_25279.n35 0.016125
R339 a_12100_25279.n20 a_12100_25279.n18 0.1255
R340 a_12100_25279.n44 a_12100_25279.n37 9.37912
R341 a_12100_25279.n0 a_12100_25279.n38 22.5627
R342 a_12100_25279.n43 a_12100_25279.n38 285.877
R343 a_12100_25279.n39 a_12100_25279.n22 13.2471
R344 a_12100_25279.n43 a_12100_25279.n39 285.877
R345 a_12100_25279.n40 a_12100_25279.n26 13.2471
R346 a_12100_25279.n43 a_12100_25279.n40 285.877
R347 a_12100_25279.n41 a_12100_25279.n30 13.2471
R348 a_12100_25279.n43 a_12100_25279.n41 285.877
R349 a_12100_25279.n42 a_12100_25279.n34 13.2471
R350 a_12100_25279.n42 a_12100_25279.n43 285.877
R351 a_12100_25279.n43 a_12100_25279.n37 585
R352 a_12100_25279.n38 a_12100_25279.n21 13.2471
R353 a_12100_25279.n21 a_12100_25279.n22 27.1064
R354 a_12100_25279.n24 a_12100_25279.n39 13.2471
R355 a_12100_25279.n24 a_12100_25279.n26 27.1064
R356 a_12100_25279.n28 a_12100_25279.n40 13.2471
R357 a_12100_25279.n28 a_12100_25279.n30 27.1064
R358 a_12100_25279.n32 a_12100_25279.n41 13.2471
R359 a_12100_25279.n32 a_12100_25279.n34 27.1064
R360 a_12100_25279.n36 a_12100_25279.n42 13.2471
R361 a_12100_25279.n36 a_12100_25279.n37 27.1064
R362 a_12100_25279.n43 a_12100_25279.t6 7.388
R363 a_6537_25279.t8 a_6537_25279.n45 135.567
R364 a_6537_25279.n45 a_6537_25279.n91 0.46027
R365 a_6537_25279.n91 a_6537_25279.n137 0.489006
R366 a_6537_25279.n137 a_6537_25279.n183 0.489006
R367 a_6537_25279.n184 a_6537_25279.n185 0.0618108
R368 a_6537_25279.n186 a_6537_25279.n187 4.5005
R369 a_6537_25279.n188 a_6537_25279.n189 4.5005
R370 a_6537_25279.n190 a_6537_25279.n191 4.5005
R371 a_6537_25279.n192 a_6537_25279.n193 4.5005
R372 a_6537_25279.n194 a_6537_25279.n195 4.5005
R373 a_6537_25279.n196 a_6537_25279.n197 4.5005
R374 a_6537_25279.n198 a_6537_25279.n199 4.5005
R375 a_6537_25279.n200 a_6537_25279.n201 4.5005
R376 a_6537_25279.n202 a_6537_25279.n203 4.5005
R377 a_6537_25279.n228 a_6537_25279.n227 4.5005
R378 a_6537_25279.n187 a_6537_25279.n184 2.376
R379 a_6537_25279.n189 a_6537_25279.n187 0.1255
R380 a_6537_25279.n191 a_6537_25279.n189 0.1255
R381 a_6537_25279.n193 a_6537_25279.n191 0.1255
R382 a_6537_25279.n195 a_6537_25279.n193 0.1255
R383 a_6537_25279.n197 a_6537_25279.n195 0.1255
R384 a_6537_25279.n199 a_6537_25279.n197 0.1255
R385 a_6537_25279.n201 a_6537_25279.n199 0.1255
R386 a_6537_25279.n203 a_6537_25279.n201 0.1255
R387 a_6537_25279.n228 a_6537_25279.n203 0.1255
R388 a_6537_25279.n183 a_6537_25279.n228 0.653113
R389 a_6537_25279.n185 a_6537_25279.n204 9.3005
R390 a_6537_25279.n206 a_6537_25279.n205 9.3005
R391 a_6537_25279.n208 a_6537_25279.n207 9.3005
R392 a_6537_25279.n210 a_6537_25279.n209 9.3005
R393 a_6537_25279.n212 a_6537_25279.n211 9.3005
R394 a_6537_25279.n214 a_6537_25279.n213 9.3005
R395 a_6537_25279.n216 a_6537_25279.n215 9.3005
R396 a_6537_25279.n218 a_6537_25279.n217 9.3005
R397 a_6537_25279.n202 a_6537_25279.n219 9.3005
R398 a_6537_25279.n221 a_6537_25279.n184 22.6257
R399 a_6537_25279.n185 a_6537_25279.n186 0.1255
R400 a_6537_25279.n186 a_6537_25279.n206 0.016125
R401 a_6537_25279.n206 a_6537_25279.n188 0.109875
R402 a_6537_25279.n188 a_6537_25279.n208 0.03175
R403 a_6537_25279.n208 a_6537_25279.n190 0.09425
R404 a_6537_25279.n190 a_6537_25279.n210 0.047375
R405 a_6537_25279.n210 a_6537_25279.n192 0.078625
R406 a_6537_25279.n192 a_6537_25279.n212 0.063
R407 a_6537_25279.n212 a_6537_25279.n194 0.063
R408 a_6537_25279.n194 a_6537_25279.n214 0.078625
R409 a_6537_25279.n214 a_6537_25279.n196 0.047375
R410 a_6537_25279.n196 a_6537_25279.n216 0.09425
R411 a_6537_25279.n216 a_6537_25279.n198 0.03175
R412 a_6537_25279.n198 a_6537_25279.n218 0.109875
R413 a_6537_25279.n218 a_6537_25279.n200 0.016125
R414 a_6537_25279.n200 a_6537_25279.n202 0.1255
R415 a_6537_25279.n227 a_6537_25279.n202 0.1255
R416 a_6537_25279.n227 a_6537_25279.n220 9.31613
R417 a_6537_25279.n221 a_6537_25279.n226 285.877
R418 a_6537_25279.n205 a_6537_25279.n222 13.2471
R419 a_6537_25279.n226 a_6537_25279.n222 285.877
R420 a_6537_25279.n209 a_6537_25279.n223 13.2471
R421 a_6537_25279.n226 a_6537_25279.n223 285.877
R422 a_6537_25279.n213 a_6537_25279.n224 13.2471
R423 a_6537_25279.n226 a_6537_25279.n224 285.877
R424 a_6537_25279.n217 a_6537_25279.n225 13.2471
R425 a_6537_25279.n226 a_6537_25279.n225 285.877
R426 a_6537_25279.n226 a_6537_25279.n220 585
R427 a_6537_25279.n204 a_6537_25279.n221 13.2471
R428 a_6537_25279.n204 a_6537_25279.n205 27.1064
R429 a_6537_25279.n222 a_6537_25279.n207 13.2471
R430 a_6537_25279.n207 a_6537_25279.n209 27.1064
R431 a_6537_25279.n223 a_6537_25279.n211 13.2471
R432 a_6537_25279.n211 a_6537_25279.n213 27.1064
R433 a_6537_25279.n224 a_6537_25279.n215 13.2471
R434 a_6537_25279.n215 a_6537_25279.n217 27.1064
R435 a_6537_25279.n225 a_6537_25279.n219 13.2471
R436 a_6537_25279.n219 a_6537_25279.n220 27.1064
R437 a_6537_25279.n226 a_6537_25279.t4 7.388
R438 a_6537_25279.n139 a_6537_25279.n138 4.5005
R439 a_6537_25279.n140 a_6537_25279.n141 0.0618108
R440 a_6537_25279.n142 a_6537_25279.n143 4.5005
R441 a_6537_25279.n144 a_6537_25279.n145 4.5005
R442 a_6537_25279.n146 a_6537_25279.n147 4.5005
R443 a_6537_25279.n148 a_6537_25279.n149 4.5005
R444 a_6537_25279.n150 a_6537_25279.n151 4.5005
R445 a_6537_25279.n152 a_6537_25279.n153 4.5005
R446 a_6537_25279.n154 a_6537_25279.n155 4.5005
R447 a_6537_25279.n156 a_6537_25279.n157 4.5005
R448 a_6537_25279.n158 a_6537_25279.n182 4.5005
R449 a_6537_25279.n143 a_6537_25279.n140 2.376
R450 a_6537_25279.n145 a_6537_25279.n143 0.1255
R451 a_6537_25279.n147 a_6537_25279.n145 0.1255
R452 a_6537_25279.n149 a_6537_25279.n147 0.1255
R453 a_6537_25279.n151 a_6537_25279.n149 0.1255
R454 a_6537_25279.n153 a_6537_25279.n151 0.1255
R455 a_6537_25279.n155 a_6537_25279.n153 0.1255
R456 a_6537_25279.n157 a_6537_25279.n155 0.1255
R457 a_6537_25279.n182 a_6537_25279.n157 0.1255
R458 a_6537_25279.n139 a_6537_25279.n182 0.1255
R459 a_6537_25279.n183 a_6537_25279.n139 0.191906
R460 a_6537_25279.n158 a_6537_25279.n159 9.3005
R461 a_6537_25279.n161 a_6537_25279.n160 9.3005
R462 a_6537_25279.n163 a_6537_25279.n162 9.3005
R463 a_6537_25279.n165 a_6537_25279.n164 9.3005
R464 a_6537_25279.n167 a_6537_25279.n166 9.3005
R465 a_6537_25279.n169 a_6537_25279.n168 9.3005
R466 a_6537_25279.n171 a_6537_25279.n170 9.3005
R467 a_6537_25279.n173 a_6537_25279.n172 9.3005
R468 a_6537_25279.n141 a_6537_25279.n174 9.3005
R469 a_6537_25279.n140 a_6537_25279.n175 9.37912
R470 a_6537_25279.n141 a_6537_25279.n142 0.1255
R471 a_6537_25279.n142 a_6537_25279.n173 0.016125
R472 a_6537_25279.n173 a_6537_25279.n144 0.109875
R473 a_6537_25279.n144 a_6537_25279.n171 0.03175
R474 a_6537_25279.n171 a_6537_25279.n146 0.09425
R475 a_6537_25279.n146 a_6537_25279.n169 0.047375
R476 a_6537_25279.n169 a_6537_25279.n148 0.078625
R477 a_6537_25279.n148 a_6537_25279.n167 0.063
R478 a_6537_25279.n167 a_6537_25279.n150 0.063
R479 a_6537_25279.n150 a_6537_25279.n165 0.078625
R480 a_6537_25279.n165 a_6537_25279.n152 0.047375
R481 a_6537_25279.n152 a_6537_25279.n163 0.09425
R482 a_6537_25279.n163 a_6537_25279.n154 0.03175
R483 a_6537_25279.n154 a_6537_25279.n161 0.109875
R484 a_6537_25279.n161 a_6537_25279.n156 0.016125
R485 a_6537_25279.n156 a_6537_25279.n158 0.1255
R486 a_6537_25279.n138 a_6537_25279.n158 0.1255
R487 a_6537_25279.n181 a_6537_25279.n180 285.877
R488 a_6537_25279.n180 a_6537_25279.n159 13.2471
R489 a_6537_25279.n181 a_6537_25279.n179 285.877
R490 a_6537_25279.n162 a_6537_25279.n179 13.2471
R491 a_6537_25279.n181 a_6537_25279.n178 285.877
R492 a_6537_25279.n166 a_6537_25279.n178 13.2471
R493 a_6537_25279.n181 a_6537_25279.n177 285.877
R494 a_6537_25279.n170 a_6537_25279.n177 13.2471
R495 a_6537_25279.n176 a_6537_25279.n181 285.877
R496 a_6537_25279.n174 a_6537_25279.n176 13.2471
R497 a_6537_25279.n181 a_6537_25279.n175 585
R498 a_6537_25279.n175 a_6537_25279.n174 27.1064
R499 a_6537_25279.n176 a_6537_25279.n172 13.2471
R500 a_6537_25279.n172 a_6537_25279.n170 27.1064
R501 a_6537_25279.n177 a_6537_25279.n168 13.2471
R502 a_6537_25279.n168 a_6537_25279.n166 27.1064
R503 a_6537_25279.n178 a_6537_25279.n164 13.2471
R504 a_6537_25279.n164 a_6537_25279.n162 27.1064
R505 a_6537_25279.n179 a_6537_25279.n160 13.2471
R506 a_6537_25279.n160 a_6537_25279.n159 27.1064
R507 a_6537_25279.n138 a_6537_25279.n180 22.5627
R508 a_6537_25279.n181 a_6537_25279.t7 12.313
R509 a_6537_25279.n181 a_6537_25279.t5 12.313
R510 a_6537_25279.n93 a_6537_25279.n92 4.5005
R511 a_6537_25279.n94 a_6537_25279.n95 0.0618108
R512 a_6537_25279.n96 a_6537_25279.n97 4.5005
R513 a_6537_25279.n98 a_6537_25279.n99 4.5005
R514 a_6537_25279.n100 a_6537_25279.n101 4.5005
R515 a_6537_25279.n102 a_6537_25279.n103 4.5005
R516 a_6537_25279.n104 a_6537_25279.n105 4.5005
R517 a_6537_25279.n106 a_6537_25279.n107 4.5005
R518 a_6537_25279.n108 a_6537_25279.n109 4.5005
R519 a_6537_25279.n110 a_6537_25279.n111 4.5005
R520 a_6537_25279.n136 a_6537_25279.n112 4.5005
R521 a_6537_25279.n97 a_6537_25279.n94 2.376
R522 a_6537_25279.n99 a_6537_25279.n97 0.1255
R523 a_6537_25279.n101 a_6537_25279.n99 0.1255
R524 a_6537_25279.n103 a_6537_25279.n101 0.1255
R525 a_6537_25279.n105 a_6537_25279.n103 0.1255
R526 a_6537_25279.n107 a_6537_25279.n105 0.1255
R527 a_6537_25279.n109 a_6537_25279.n107 0.1255
R528 a_6537_25279.n111 a_6537_25279.n109 0.1255
R529 a_6537_25279.n136 a_6537_25279.n111 0.1255
R530 a_6537_25279.n93 a_6537_25279.n136 0.1255
R531 a_6537_25279.n137 a_6537_25279.n93 0.191906
R532 a_6537_25279.n112 a_6537_25279.n113 9.3005
R533 a_6537_25279.n115 a_6537_25279.n114 9.3005
R534 a_6537_25279.n117 a_6537_25279.n116 9.3005
R535 a_6537_25279.n119 a_6537_25279.n118 9.3005
R536 a_6537_25279.n121 a_6537_25279.n120 9.3005
R537 a_6537_25279.n123 a_6537_25279.n122 9.3005
R538 a_6537_25279.n125 a_6537_25279.n124 9.3005
R539 a_6537_25279.n127 a_6537_25279.n126 9.3005
R540 a_6537_25279.n95 a_6537_25279.n128 9.3005
R541 a_6537_25279.n94 a_6537_25279.n129 9.37912
R542 a_6537_25279.n95 a_6537_25279.n96 0.1255
R543 a_6537_25279.n96 a_6537_25279.n127 0.016125
R544 a_6537_25279.n127 a_6537_25279.n98 0.109875
R545 a_6537_25279.n98 a_6537_25279.n125 0.03175
R546 a_6537_25279.n125 a_6537_25279.n100 0.09425
R547 a_6537_25279.n100 a_6537_25279.n123 0.047375
R548 a_6537_25279.n123 a_6537_25279.n102 0.078625
R549 a_6537_25279.n102 a_6537_25279.n121 0.063
R550 a_6537_25279.n121 a_6537_25279.n104 0.063
R551 a_6537_25279.n104 a_6537_25279.n119 0.078625
R552 a_6537_25279.n119 a_6537_25279.n106 0.047375
R553 a_6537_25279.n106 a_6537_25279.n117 0.09425
R554 a_6537_25279.n117 a_6537_25279.n108 0.03175
R555 a_6537_25279.n108 a_6537_25279.n115 0.109875
R556 a_6537_25279.n115 a_6537_25279.n110 0.016125
R557 a_6537_25279.n110 a_6537_25279.n112 0.1255
R558 a_6537_25279.n112 a_6537_25279.n92 0.1255
R559 a_6537_25279.n135 a_6537_25279.n134 285.877
R560 a_6537_25279.n134 a_6537_25279.n113 13.2471
R561 a_6537_25279.n135 a_6537_25279.n133 285.877
R562 a_6537_25279.n116 a_6537_25279.n133 13.2471
R563 a_6537_25279.n135 a_6537_25279.n132 285.877
R564 a_6537_25279.n120 a_6537_25279.n132 13.2471
R565 a_6537_25279.n135 a_6537_25279.n131 285.877
R566 a_6537_25279.n124 a_6537_25279.n131 13.2471
R567 a_6537_25279.n130 a_6537_25279.n135 285.877
R568 a_6537_25279.n128 a_6537_25279.n130 13.2471
R569 a_6537_25279.n135 a_6537_25279.n129 585
R570 a_6537_25279.n129 a_6537_25279.n128 27.1064
R571 a_6537_25279.n130 a_6537_25279.n126 13.2471
R572 a_6537_25279.n126 a_6537_25279.n124 27.1064
R573 a_6537_25279.n131 a_6537_25279.n122 13.2471
R574 a_6537_25279.n122 a_6537_25279.n120 27.1064
R575 a_6537_25279.n132 a_6537_25279.n118 13.2471
R576 a_6537_25279.n118 a_6537_25279.n116 27.1064
R577 a_6537_25279.n133 a_6537_25279.n114 13.2471
R578 a_6537_25279.n114 a_6537_25279.n113 27.1064
R579 a_6537_25279.n92 a_6537_25279.n134 22.5627
R580 a_6537_25279.n135 a_6537_25279.t3 12.313
R581 a_6537_25279.n135 a_6537_25279.t1 12.313
R582 a_6537_25279.n47 a_6537_25279.n46 4.5005
R583 a_6537_25279.n48 a_6537_25279.n49 0.0618108
R584 a_6537_25279.n50 a_6537_25279.n51 4.5005
R585 a_6537_25279.n52 a_6537_25279.n53 4.5005
R586 a_6537_25279.n54 a_6537_25279.n55 4.5005
R587 a_6537_25279.n56 a_6537_25279.n57 4.5005
R588 a_6537_25279.n58 a_6537_25279.n59 4.5005
R589 a_6537_25279.n60 a_6537_25279.n61 4.5005
R590 a_6537_25279.n62 a_6537_25279.n63 4.5005
R591 a_6537_25279.n64 a_6537_25279.n65 4.5005
R592 a_6537_25279.n90 a_6537_25279.n66 4.5005
R593 a_6537_25279.n51 a_6537_25279.n48 2.376
R594 a_6537_25279.n53 a_6537_25279.n51 0.1255
R595 a_6537_25279.n55 a_6537_25279.n53 0.1255
R596 a_6537_25279.n57 a_6537_25279.n55 0.1255
R597 a_6537_25279.n59 a_6537_25279.n57 0.1255
R598 a_6537_25279.n61 a_6537_25279.n59 0.1255
R599 a_6537_25279.n63 a_6537_25279.n61 0.1255
R600 a_6537_25279.n65 a_6537_25279.n63 0.1255
R601 a_6537_25279.n90 a_6537_25279.n65 0.1255
R602 a_6537_25279.n47 a_6537_25279.n90 0.1255
R603 a_6537_25279.n91 a_6537_25279.n47 0.191906
R604 a_6537_25279.n66 a_6537_25279.n67 9.3005
R605 a_6537_25279.n69 a_6537_25279.n68 9.3005
R606 a_6537_25279.n71 a_6537_25279.n70 9.3005
R607 a_6537_25279.n73 a_6537_25279.n72 9.3005
R608 a_6537_25279.n75 a_6537_25279.n74 9.3005
R609 a_6537_25279.n77 a_6537_25279.n76 9.3005
R610 a_6537_25279.n79 a_6537_25279.n78 9.3005
R611 a_6537_25279.n81 a_6537_25279.n80 9.3005
R612 a_6537_25279.n49 a_6537_25279.n82 9.3005
R613 a_6537_25279.n48 a_6537_25279.n83 9.37912
R614 a_6537_25279.n49 a_6537_25279.n50 0.1255
R615 a_6537_25279.n50 a_6537_25279.n81 0.016125
R616 a_6537_25279.n81 a_6537_25279.n52 0.109875
R617 a_6537_25279.n52 a_6537_25279.n79 0.03175
R618 a_6537_25279.n79 a_6537_25279.n54 0.09425
R619 a_6537_25279.n54 a_6537_25279.n77 0.047375
R620 a_6537_25279.n77 a_6537_25279.n56 0.078625
R621 a_6537_25279.n56 a_6537_25279.n75 0.063
R622 a_6537_25279.n75 a_6537_25279.n58 0.063
R623 a_6537_25279.n58 a_6537_25279.n73 0.078625
R624 a_6537_25279.n73 a_6537_25279.n60 0.047375
R625 a_6537_25279.n60 a_6537_25279.n71 0.09425
R626 a_6537_25279.n71 a_6537_25279.n62 0.03175
R627 a_6537_25279.n62 a_6537_25279.n69 0.109875
R628 a_6537_25279.n69 a_6537_25279.n64 0.016125
R629 a_6537_25279.n64 a_6537_25279.n66 0.1255
R630 a_6537_25279.n66 a_6537_25279.n46 0.1255
R631 a_6537_25279.n89 a_6537_25279.n88 285.877
R632 a_6537_25279.n88 a_6537_25279.n67 13.2471
R633 a_6537_25279.n89 a_6537_25279.n87 285.877
R634 a_6537_25279.n70 a_6537_25279.n87 13.2471
R635 a_6537_25279.n89 a_6537_25279.n86 285.877
R636 a_6537_25279.n74 a_6537_25279.n86 13.2471
R637 a_6537_25279.n89 a_6537_25279.n85 285.877
R638 a_6537_25279.n78 a_6537_25279.n85 13.2471
R639 a_6537_25279.n84 a_6537_25279.n89 285.877
R640 a_6537_25279.n82 a_6537_25279.n84 13.2471
R641 a_6537_25279.n89 a_6537_25279.n83 585
R642 a_6537_25279.n83 a_6537_25279.n82 27.1064
R643 a_6537_25279.n84 a_6537_25279.n80 13.2471
R644 a_6537_25279.n80 a_6537_25279.n78 27.1064
R645 a_6537_25279.n85 a_6537_25279.n76 13.2471
R646 a_6537_25279.n76 a_6537_25279.n74 27.1064
R647 a_6537_25279.n86 a_6537_25279.n72 13.2471
R648 a_6537_25279.n72 a_6537_25279.n70 27.1064
R649 a_6537_25279.n87 a_6537_25279.n68 13.2471
R650 a_6537_25279.n68 a_6537_25279.n67 27.1064
R651 a_6537_25279.n46 a_6537_25279.n88 22.5627
R652 a_6537_25279.n89 a_6537_25279.t2 12.313
R653 a_6537_25279.n89 a_6537_25279.t0 12.313
R654 a_6537_25279.n1 a_6537_25279.n0 4.5005
R655 a_6537_25279.n2 a_6537_25279.n3 0.0618108
R656 a_6537_25279.n4 a_6537_25279.n5 4.5005
R657 a_6537_25279.n6 a_6537_25279.n7 4.5005
R658 a_6537_25279.n8 a_6537_25279.n9 4.5005
R659 a_6537_25279.n10 a_6537_25279.n11 4.5005
R660 a_6537_25279.n12 a_6537_25279.n13 4.5005
R661 a_6537_25279.n14 a_6537_25279.n15 4.5005
R662 a_6537_25279.n16 a_6537_25279.n17 4.5005
R663 a_6537_25279.n18 a_6537_25279.n19 4.5005
R664 a_6537_25279.n20 a_6537_25279.n44 4.5005
R665 a_6537_25279.n5 a_6537_25279.n2 2.376
R666 a_6537_25279.n7 a_6537_25279.n5 0.1255
R667 a_6537_25279.n9 a_6537_25279.n7 0.1255
R668 a_6537_25279.n11 a_6537_25279.n9 0.1255
R669 a_6537_25279.n13 a_6537_25279.n11 0.1255
R670 a_6537_25279.n15 a_6537_25279.n13 0.1255
R671 a_6537_25279.n17 a_6537_25279.n15 0.1255
R672 a_6537_25279.n19 a_6537_25279.n17 0.1255
R673 a_6537_25279.n44 a_6537_25279.n19 0.1255
R674 a_6537_25279.n1 a_6537_25279.n44 0.1255
R675 a_6537_25279.n45 a_6537_25279.n1 0.191906
R676 a_6537_25279.n20 a_6537_25279.n21 9.3005
R677 a_6537_25279.n23 a_6537_25279.n22 9.3005
R678 a_6537_25279.n25 a_6537_25279.n24 9.3005
R679 a_6537_25279.n27 a_6537_25279.n26 9.3005
R680 a_6537_25279.n29 a_6537_25279.n28 9.3005
R681 a_6537_25279.n31 a_6537_25279.n30 9.3005
R682 a_6537_25279.n33 a_6537_25279.n32 9.3005
R683 a_6537_25279.n35 a_6537_25279.n34 9.3005
R684 a_6537_25279.n3 a_6537_25279.n36 9.3005
R685 a_6537_25279.n2 a_6537_25279.n37 9.37912
R686 a_6537_25279.n3 a_6537_25279.n4 0.1255
R687 a_6537_25279.n4 a_6537_25279.n35 0.016125
R688 a_6537_25279.n35 a_6537_25279.n6 0.109875
R689 a_6537_25279.n6 a_6537_25279.n33 0.03175
R690 a_6537_25279.n33 a_6537_25279.n8 0.09425
R691 a_6537_25279.n8 a_6537_25279.n31 0.047375
R692 a_6537_25279.n31 a_6537_25279.n10 0.078625
R693 a_6537_25279.n10 a_6537_25279.n29 0.063
R694 a_6537_25279.n29 a_6537_25279.n12 0.063
R695 a_6537_25279.n12 a_6537_25279.n27 0.078625
R696 a_6537_25279.n27 a_6537_25279.n14 0.047375
R697 a_6537_25279.n14 a_6537_25279.n25 0.09425
R698 a_6537_25279.n25 a_6537_25279.n16 0.03175
R699 a_6537_25279.n16 a_6537_25279.n23 0.109875
R700 a_6537_25279.n23 a_6537_25279.n18 0.016125
R701 a_6537_25279.n18 a_6537_25279.n20 0.1255
R702 a_6537_25279.n0 a_6537_25279.n20 0.1255
R703 a_6537_25279.n43 a_6537_25279.n42 285.877
R704 a_6537_25279.n42 a_6537_25279.n21 13.2471
R705 a_6537_25279.n43 a_6537_25279.n41 285.877
R706 a_6537_25279.n24 a_6537_25279.n41 13.2471
R707 a_6537_25279.n43 a_6537_25279.n40 285.877
R708 a_6537_25279.n28 a_6537_25279.n40 13.2471
R709 a_6537_25279.n43 a_6537_25279.n39 285.877
R710 a_6537_25279.n32 a_6537_25279.n39 13.2471
R711 a_6537_25279.n38 a_6537_25279.n43 285.877
R712 a_6537_25279.n36 a_6537_25279.n38 13.2471
R713 a_6537_25279.n43 a_6537_25279.n37 585
R714 a_6537_25279.n37 a_6537_25279.n36 27.1064
R715 a_6537_25279.n38 a_6537_25279.n34 13.2471
R716 a_6537_25279.n34 a_6537_25279.n32 27.1064
R717 a_6537_25279.n39 a_6537_25279.n30 13.2471
R718 a_6537_25279.n30 a_6537_25279.n28 27.1064
R719 a_6537_25279.n40 a_6537_25279.n26 13.2471
R720 a_6537_25279.n26 a_6537_25279.n24 27.1064
R721 a_6537_25279.n41 a_6537_25279.n22 13.2471
R722 a_6537_25279.n22 a_6537_25279.n21 27.1064
R723 a_6537_25279.n0 a_6537_25279.n42 22.5627
R724 a_6537_25279.n43 a_6537_25279.t6 7.388
R725 w_11843_25095.t15 w_11843_25095.n0 12.313
R726 w_11843_25095.n0 w_11843_25095.t13 12.313
R727 w_11843_25095.n0 w_11843_25095.n208 54.9662
R728 w_11843_25095.n2 w_11843_25095.n1 9.3005
R729 w_11843_25095.n4 w_11843_25095.n3 9.3005
R730 w_11843_25095.n6 w_11843_25095.n5 9.3005
R731 w_11843_25095.n8 w_11843_25095.n7 9.3005
R732 w_11843_25095.n10 w_11843_25095.n9 9.3005
R733 w_11843_25095.n12 w_11843_25095.n11 9.3005
R734 w_11843_25095.n14 w_11843_25095.n13 9.3005
R735 w_11843_25095.n16 w_11843_25095.n15 9.3005
R736 w_11843_25095.n18 w_11843_25095.n17 9.3005
R737 w_11843_25095.n20 w_11843_25095.n19 9.3005
R738 w_11843_25095.n22 w_11843_25095.n21 9.3005
R739 w_11843_25095.n24 w_11843_25095.n23 9.3005
R740 w_11843_25095.n26 w_11843_25095.n25 9.3005
R741 w_11843_25095.n28 w_11843_25095.n27 9.3005
R742 w_11843_25095.n208 w_11843_25095.n2 0.0173129
R743 w_11843_25095.n2 w_11843_25095.n4 0.0531316
R744 w_11843_25095.n4 w_11843_25095.n6 0.0531316
R745 w_11843_25095.n6 w_11843_25095.n8 0.0531316
R746 w_11843_25095.n8 w_11843_25095.n10 0.0531316
R747 w_11843_25095.n10 w_11843_25095.n31 0.0216988
R748 w_11843_25095.n31 w_11843_25095.n12 0.0319327
R749 w_11843_25095.n12 w_11843_25095.n14 0.0531316
R750 w_11843_25095.n14 w_11843_25095.n16 0.0531316
R751 w_11843_25095.n16 w_11843_25095.n18 0.0531316
R752 w_11843_25095.n18 w_11843_25095.n20 0.0531316
R753 w_11843_25095.n20 w_11843_25095.n33 0.00707895
R754 w_11843_25095.n33 w_11843_25095.n22 0.0465526
R755 w_11843_25095.n22 w_11843_25095.n24 0.0531316
R756 w_11843_25095.n24 w_11843_25095.n26 0.0531316
R757 w_11843_25095.n26 w_11843_25095.n28 0.0531316
R758 w_11843_25095.n28 w_11843_25095.n35 0.0450906
R759 w_11843_25095.n35 w_11843_25095.n29 9.30854
R760 w_11843_25095.n208 w_11843_25095.n207 9.38231
R761 w_11843_25095.n37 w_11843_25095.n36 185
R762 w_11843_25095.n38 w_11843_25095.n37 185
R763 w_11843_25095.n40 w_11843_25095.n39 185
R764 w_11843_25095.n41 w_11843_25095.n40 185
R765 w_11843_25095.n43 w_11843_25095.n42 185
R766 w_11843_25095.n44 w_11843_25095.n43 185
R767 w_11843_25095.n46 w_11843_25095.n45 185
R768 w_11843_25095.n47 w_11843_25095.n46 185
R769 w_11843_25095.n49 w_11843_25095.n48 185
R770 w_11843_25095.n50 w_11843_25095.n49 185
R771 w_11843_25095.n52 w_11843_25095.n51 185
R772 w_11843_25095.n53 w_11843_25095.n52 185
R773 w_11843_25095.n55 w_11843_25095.n54 185
R774 w_11843_25095.n56 w_11843_25095.n55 185
R775 w_11843_25095.n58 w_11843_25095.n57 185
R776 w_11843_25095.n59 w_11843_25095.n58 185
R777 w_11843_25095.n61 w_11843_25095.n60 185
R778 w_11843_25095.n62 w_11843_25095.n61 185
R779 w_11843_25095.n64 w_11843_25095.n63 185
R780 w_11843_25095.n65 w_11843_25095.n64 185
R781 w_11843_25095.n67 w_11843_25095.n66 185
R782 w_11843_25095.n68 w_11843_25095.n67 185
R783 w_11843_25095.n70 w_11843_25095.n69 185
R784 w_11843_25095.n71 w_11843_25095.n70 185
R785 w_11843_25095.n73 w_11843_25095.n72 185
R786 w_11843_25095.n74 w_11843_25095.n73 185
R787 w_11843_25095.n76 w_11843_25095.n75 185
R788 w_11843_25095.n77 w_11843_25095.n76 185
R789 w_11843_25095.n79 w_11843_25095.n78 185
R790 w_11843_25095.n80 w_11843_25095.n79 185
R791 w_11843_25095.n82 w_11843_25095.n81 185
R792 w_11843_25095.n83 w_11843_25095.n82 185
R793 w_11843_25095.n85 w_11843_25095.n84 185
R794 w_11843_25095.n86 w_11843_25095.n85 185
R795 w_11843_25095.n207 w_11843_25095.n86 4.3525
R796 w_11843_25095.n207 w_11843_25095.n83 14.0805
R797 w_11843_25095.n1 w_11843_25095.n83 4.3525
R798 w_11843_25095.n1 w_11843_25095.n80 14.0805
R799 w_11843_25095.n3 w_11843_25095.n80 4.3525
R800 w_11843_25095.n3 w_11843_25095.n77 14.0805
R801 w_11843_25095.n5 w_11843_25095.n77 4.3525
R802 w_11843_25095.n5 w_11843_25095.n74 14.0805
R803 w_11843_25095.n7 w_11843_25095.n74 4.3525
R804 w_11843_25095.n7 w_11843_25095.n71 14.0805
R805 w_11843_25095.n9 w_11843_25095.n71 4.3525
R806 w_11843_25095.n9 w_11843_25095.n68 14.0805
R807 w_11843_25095.n11 w_11843_25095.n68 4.3525
R808 w_11843_25095.n11 w_11843_25095.n65 14.0805
R809 w_11843_25095.n13 w_11843_25095.n65 4.3525
R810 w_11843_25095.n13 w_11843_25095.n62 14.0805
R811 w_11843_25095.n15 w_11843_25095.n62 4.3525
R812 w_11843_25095.n15 w_11843_25095.n59 14.0805
R813 w_11843_25095.n17 w_11843_25095.n59 4.3525
R814 w_11843_25095.n17 w_11843_25095.n56 14.0805
R815 w_11843_25095.n19 w_11843_25095.n56 4.3525
R816 w_11843_25095.n19 w_11843_25095.n53 14.0805
R817 w_11843_25095.n21 w_11843_25095.n53 4.3525
R818 w_11843_25095.n21 w_11843_25095.n50 14.0805
R819 w_11843_25095.n23 w_11843_25095.n50 4.3525
R820 w_11843_25095.n23 w_11843_25095.n47 14.0805
R821 w_11843_25095.n25 w_11843_25095.n47 4.3525
R822 w_11843_25095.n25 w_11843_25095.n44 14.0805
R823 w_11843_25095.n27 w_11843_25095.n44 4.3525
R824 w_11843_25095.n27 w_11843_25095.n41 14.0805
R825 w_11843_25095.n29 w_11843_25095.n41 4.3525
R826 w_11843_25095.n29 w_11843_25095.n38 14.0805
R827 w_11843_25095.n88 w_11843_25095.n87 185
R828 w_11843_25095.n89 w_11843_25095.n88 185
R829 w_11843_25095.n91 w_11843_25095.n90 185
R830 w_11843_25095.n92 w_11843_25095.n91 185
R831 w_11843_25095.n89 w_11843_25095.n92 27.1064
R832 w_11843_25095.n86 w_11843_25095.n89 21.9261
R833 w_11843_25095.n93 w_11843_25095.n94 185
R834 w_11843_25095.n95 w_11843_25095.n94 185
R835 w_11843_25095.n96 w_11843_25095.n98 75.3262
R836 w_11843_25095.n97 w_11843_25095.n96 185
R837 w_11843_25095.n98 w_11843_25095.n93 54.8384
R838 w_11843_25095.n100 w_11843_25095.n99 185
R839 w_11843_25095.n101 w_11843_25095.n103 75.3262
R840 w_11843_25095.n102 w_11843_25095.n101 185
R841 w_11843_25095.n93 w_11843_25095.n103 54.8384
R842 w_11843_25095.n105 w_11843_25095.n104 185
R843 w_11843_25095.n106 w_11843_25095.n108 75.3262
R844 w_11843_25095.n107 w_11843_25095.n106 185
R845 w_11843_25095.n93 w_11843_25095.n108 54.8384
R846 w_11843_25095.n110 w_11843_25095.n109 185
R847 w_11843_25095.n113 w_11843_25095.n111 75.3262
R848 w_11843_25095.n112 w_11843_25095.n111 185
R849 w_11843_25095.n93 w_11843_25095.n113 54.8384
R850 w_11843_25095.n115 w_11843_25095.n114 185
R851 w_11843_25095.n118 w_11843_25095.n116 75.3262
R852 w_11843_25095.n117 w_11843_25095.n116 185
R853 w_11843_25095.n93 w_11843_25095.n118 54.8384
R854 w_11843_25095.n120 w_11843_25095.n119 185
R855 w_11843_25095.n123 w_11843_25095.n121 75.3262
R856 w_11843_25095.n121 w_11843_25095.n122 185
R857 w_11843_25095.n93 w_11843_25095.n123 54.8384
R858 w_11843_25095.n124 w_11843_25095.n125 185
R859 w_11843_25095.n122 w_11843_25095.n125 27.1064
R860 w_11843_25095.n120 w_11843_25095.n122 27.1064
R861 w_11843_25095.n117 w_11843_25095.n120 27.1064
R862 w_11843_25095.n115 w_11843_25095.n117 27.1064
R863 w_11843_25095.n112 w_11843_25095.n115 27.1064
R864 w_11843_25095.n110 w_11843_25095.n112 27.1064
R865 w_11843_25095.n107 w_11843_25095.n110 27.1064
R866 w_11843_25095.n105 w_11843_25095.n107 27.1064
R867 w_11843_25095.n102 w_11843_25095.n105 27.1064
R868 w_11843_25095.n100 w_11843_25095.n102 27.1064
R869 w_11843_25095.n97 w_11843_25095.n100 27.1064
R870 w_11843_25095.n95 w_11843_25095.n97 27.1064
R871 w_11843_25095.n92 w_11843_25095.n95 64.7534
R872 w_11843_25095.n90 w_11843_25095.n126 185
R873 w_11843_25095.n126 w_11843_25095.n127 185
R874 w_11843_25095.n87 w_11843_25095.n128 185
R875 w_11843_25095.n128 w_11843_25095.n129 185
R876 w_11843_25095.n84 w_11843_25095.n130 185
R877 w_11843_25095.n130 w_11843_25095.n131 185
R878 w_11843_25095.n81 w_11843_25095.n132 185
R879 w_11843_25095.n132 w_11843_25095.n133 185
R880 w_11843_25095.n78 w_11843_25095.n134 185
R881 w_11843_25095.n134 w_11843_25095.n135 185
R882 w_11843_25095.n75 w_11843_25095.n136 185
R883 w_11843_25095.n136 w_11843_25095.n137 185
R884 w_11843_25095.n72 w_11843_25095.n138 185
R885 w_11843_25095.n138 w_11843_25095.n139 185
R886 w_11843_25095.n69 w_11843_25095.n140 185
R887 w_11843_25095.n140 w_11843_25095.n141 185
R888 w_11843_25095.n66 w_11843_25095.n142 185
R889 w_11843_25095.n142 w_11843_25095.n143 185
R890 w_11843_25095.n63 w_11843_25095.n144 185
R891 w_11843_25095.n144 w_11843_25095.n145 185
R892 w_11843_25095.n60 w_11843_25095.n146 185
R893 w_11843_25095.n146 w_11843_25095.n147 185
R894 w_11843_25095.n57 w_11843_25095.n148 185
R895 w_11843_25095.n148 w_11843_25095.n149 185
R896 w_11843_25095.n54 w_11843_25095.n150 185
R897 w_11843_25095.n150 w_11843_25095.n151 185
R898 w_11843_25095.n51 w_11843_25095.n152 185
R899 w_11843_25095.n152 w_11843_25095.n153 185
R900 w_11843_25095.n48 w_11843_25095.n154 185
R901 w_11843_25095.n154 w_11843_25095.n155 185
R902 w_11843_25095.n45 w_11843_25095.n156 185
R903 w_11843_25095.n156 w_11843_25095.n157 185
R904 w_11843_25095.n42 w_11843_25095.n158 185
R905 w_11843_25095.n158 w_11843_25095.n159 185
R906 w_11843_25095.n39 w_11843_25095.n160 185
R907 w_11843_25095.n160 w_11843_25095.n161 185
R908 w_11843_25095.n36 w_11843_25095.n162 185
R909 w_11843_25095.n162 w_11843_25095.n163 185
R910 w_11843_25095.n204 w_11843_25095.n164 185
R911 w_11843_25095.n164 w_11843_25095.n165 185
R912 w_11843_25095.n201 w_11843_25095.n166 185
R913 w_11843_25095.n166 w_11843_25095.n167 185
R914 w_11843_25095.n125 w_11843_25095.n127 64.7534
R915 w_11843_25095.n127 w_11843_25095.n129 27.1064
R916 w_11843_25095.n129 w_11843_25095.n131 27.1064
R917 w_11843_25095.n131 w_11843_25095.n133 27.1064
R918 w_11843_25095.n133 w_11843_25095.n135 27.1064
R919 w_11843_25095.n135 w_11843_25095.n137 27.1064
R920 w_11843_25095.n137 w_11843_25095.n139 27.1064
R921 w_11843_25095.n139 w_11843_25095.n141 27.1064
R922 w_11843_25095.n141 w_11843_25095.n143 27.1064
R923 w_11843_25095.n143 w_11843_25095.n145 27.1064
R924 w_11843_25095.n145 w_11843_25095.n147 27.1064
R925 w_11843_25095.n147 w_11843_25095.n149 27.1064
R926 w_11843_25095.n149 w_11843_25095.n151 27.1064
R927 w_11843_25095.n153 w_11843_25095.n151 27.1064
R928 w_11843_25095.n155 w_11843_25095.n153 27.1064
R929 w_11843_25095.n157 w_11843_25095.n155 27.1064
R930 w_11843_25095.n159 w_11843_25095.n157 27.1064
R931 w_11843_25095.n161 w_11843_25095.n159 27.1064
R932 w_11843_25095.n163 w_11843_25095.n161 27.1064
R933 w_11843_25095.n165 w_11843_25095.n163 27.1064
R934 w_11843_25095.n167 w_11843_25095.n165 27.1064
R935 w_11843_25095.n192 w_11843_25095.n168 75.3262
R936 w_11843_25095.n168 w_11843_25095.n169 185
R937 w_11843_25095.n197 w_11843_25095.n192 54.8384
R938 w_11843_25095.n170 w_11843_25095.n171 185
R939 w_11843_25095.n193 w_11843_25095.n172 75.3262
R940 w_11843_25095.n172 w_11843_25095.n173 185
R941 w_11843_25095.n197 w_11843_25095.n193 54.8384
R942 w_11843_25095.n175 w_11843_25095.n174 185
R943 w_11843_25095.n194 w_11843_25095.n176 75.3262
R944 w_11843_25095.n177 w_11843_25095.n176 185
R945 w_11843_25095.n197 w_11843_25095.n194 54.8384
R946 w_11843_25095.n179 w_11843_25095.n178 185
R947 w_11843_25095.n195 w_11843_25095.n180 75.3262
R948 w_11843_25095.n181 w_11843_25095.n180 185
R949 w_11843_25095.n197 w_11843_25095.n195 54.8384
R950 w_11843_25095.n183 w_11843_25095.n182 185
R951 w_11843_25095.n196 w_11843_25095.n184 75.3262
R952 w_11843_25095.n185 w_11843_25095.n184 185
R953 w_11843_25095.n197 w_11843_25095.n196 54.8384
R954 w_11843_25095.n187 w_11843_25095.n186 185
R955 w_11843_25095.n197 w_11843_25095.n188 185
R956 w_11843_25095.n189 w_11843_25095.n188 185
R957 w_11843_25095.n198 w_11843_25095.n190 75.3262
R958 w_11843_25095.n191 w_11843_25095.n190 185
R959 w_11843_25095.n198 w_11843_25095.n197 54.8384
R960 w_11843_25095.n200 w_11843_25095.n199 185
R961 w_11843_25095.n169 w_11843_25095.n167 64.7534
R962 w_11843_25095.n171 w_11843_25095.n169 27.1064
R963 w_11843_25095.n173 w_11843_25095.n171 27.1064
R964 w_11843_25095.n175 w_11843_25095.n173 27.1064
R965 w_11843_25095.n177 w_11843_25095.n175 27.1064
R966 w_11843_25095.n179 w_11843_25095.n177 27.1064
R967 w_11843_25095.n181 w_11843_25095.n179 27.1064
R968 w_11843_25095.n183 w_11843_25095.n181 27.1064
R969 w_11843_25095.n185 w_11843_25095.n183 27.1064
R970 w_11843_25095.n187 w_11843_25095.n185 27.1064
R971 w_11843_25095.n189 w_11843_25095.n187 27.1064
R972 w_11843_25095.n191 w_11843_25095.n189 27.1064
R973 w_11843_25095.n200 w_11843_25095.n191 27.1064
R974 w_11843_25095.n202 w_11843_25095.n201 185
R975 w_11843_25095.n203 w_11843_25095.n202 185
R976 w_11843_25095.n205 w_11843_25095.n204 185
R977 w_11843_25095.n206 w_11843_25095.n205 185
R978 w_11843_25095.n38 w_11843_25095.n206 26.504
R979 w_11843_25095.n206 w_11843_25095.n203 27.1064
R980 w_11843_25095.n203 w_11843_25095.n200 64.7534
R981 w_11843_25095.n91 w_11843_25095.n88 254.119
R982 w_11843_25095.n88 w_11843_25095.n85 254.119
R983 w_11843_25095.n85 w_11843_25095.n82 254.119
R984 w_11843_25095.n82 w_11843_25095.n79 254.119
R985 w_11843_25095.n79 w_11843_25095.n76 254.119
R986 w_11843_25095.n76 w_11843_25095.n73 254.119
R987 w_11843_25095.n73 w_11843_25095.n70 254.119
R988 w_11843_25095.n70 w_11843_25095.n67 254.119
R989 w_11843_25095.n67 w_11843_25095.n64 254.119
R990 w_11843_25095.n64 w_11843_25095.n61 254.119
R991 w_11843_25095.n61 w_11843_25095.n58 254.119
R992 w_11843_25095.n58 w_11843_25095.n55 254.119
R993 w_11843_25095.n55 w_11843_25095.n52 254.119
R994 w_11843_25095.n52 w_11843_25095.n49 254.119
R995 w_11843_25095.n49 w_11843_25095.n46 254.119
R996 w_11843_25095.n46 w_11843_25095.n43 254.119
R997 w_11843_25095.n43 w_11843_25095.n40 254.119
R998 w_11843_25095.n40 w_11843_25095.n37 254.119
R999 w_11843_25095.n37 w_11843_25095.n205 254.119
R1000 w_11843_25095.n205 w_11843_25095.n202 254.119
R1001 w_11843_25095.n123 w_11843_25095.n124 75.3262
R1002 w_11843_25095.n121 w_11843_25095.n119 254.119
R1003 w_11843_25095.n119 w_11843_25095.n118 75.3262
R1004 w_11843_25095.n116 w_11843_25095.n114 254.119
R1005 w_11843_25095.n114 w_11843_25095.n113 75.3262
R1006 w_11843_25095.n111 w_11843_25095.n109 254.119
R1007 w_11843_25095.n109 w_11843_25095.n108 75.3262
R1008 w_11843_25095.n106 w_11843_25095.n104 254.119
R1009 w_11843_25095.n104 w_11843_25095.n103 75.3262
R1010 w_11843_25095.n101 w_11843_25095.n99 254.119
R1011 w_11843_25095.n99 w_11843_25095.n98 75.3262
R1012 w_11843_25095.n96 w_11843_25095.n94 254.119
R1013 w_11843_25095.n94 w_11843_25095.n91 607.059
R1014 w_11843_25095.n124 w_11843_25095.n126 607.059
R1015 w_11843_25095.n126 w_11843_25095.n128 254.119
R1016 w_11843_25095.n128 w_11843_25095.n130 254.119
R1017 w_11843_25095.n130 w_11843_25095.n132 254.119
R1018 w_11843_25095.n132 w_11843_25095.n134 254.119
R1019 w_11843_25095.n134 w_11843_25095.n136 254.119
R1020 w_11843_25095.n136 w_11843_25095.n138 254.119
R1021 w_11843_25095.n138 w_11843_25095.n140 254.119
R1022 w_11843_25095.n140 w_11843_25095.n142 254.119
R1023 w_11843_25095.n142 w_11843_25095.n144 254.119
R1024 w_11843_25095.n144 w_11843_25095.n146 254.119
R1025 w_11843_25095.n146 w_11843_25095.n148 254.119
R1026 w_11843_25095.n148 w_11843_25095.n150 254.119
R1027 w_11843_25095.n150 w_11843_25095.n152 254.119
R1028 w_11843_25095.n152 w_11843_25095.n154 254.119
R1029 w_11843_25095.n154 w_11843_25095.n156 254.119
R1030 w_11843_25095.n156 w_11843_25095.n158 254.119
R1031 w_11843_25095.n158 w_11843_25095.n160 254.119
R1032 w_11843_25095.n160 w_11843_25095.n162 254.119
R1033 w_11843_25095.n162 w_11843_25095.n164 254.119
R1034 w_11843_25095.n164 w_11843_25095.n166 254.119
R1035 w_11843_25095.n166 w_11843_25095.n168 607.059
R1036 w_11843_25095.n192 w_11843_25095.n170 75.3262
R1037 w_11843_25095.n170 w_11843_25095.n172 254.119
R1038 w_11843_25095.n193 w_11843_25095.n174 75.3262
R1039 w_11843_25095.n174 w_11843_25095.n176 254.119
R1040 w_11843_25095.n194 w_11843_25095.n178 75.3262
R1041 w_11843_25095.n178 w_11843_25095.n180 254.119
R1042 w_11843_25095.n195 w_11843_25095.n182 75.3262
R1043 w_11843_25095.n182 w_11843_25095.n184 254.119
R1044 w_11843_25095.n186 w_11843_25095.n196 75.3262
R1045 w_11843_25095.n186 w_11843_25095.n188 254.119
R1046 w_11843_25095.n188 w_11843_25095.n190 254.119
R1047 w_11843_25095.n199 w_11843_25095.n198 75.3262
R1048 w_11843_25095.n199 w_11843_25095.n202 607.059
R1049 w_11843_25095.n93 w_11843_25095.n90 57.9459
R1050 w_11843_25095.n90 w_11843_25095.n87 54.8962
R1051 w_11843_25095.n87 w_11843_25095.t14 40.4098
R1052 w_11843_25095.n84 w_11843_25095.t14 14.4869
R1053 w_11843_25095.n84 w_11843_25095.n81 54.8962
R1054 w_11843_25095.n81 w_11843_25095.n78 54.8962
R1055 w_11843_25095.n78 w_11843_25095.t12 5.33758
R1056 w_11843_25095.t12 w_11843_25095.n75 49.5591
R1057 w_11843_25095.n75 w_11843_25095.n72 54.8962
R1058 w_11843_25095.n72 w_11843_25095.t10 25.161
R1059 w_11843_25095.t10 w_11843_25095.n69 29.7357
R1060 w_11843_25095.n69 w_11843_25095.n66 54.8962
R1061 w_11843_25095.n66 w_11843_25095.t8 44.9844
R1062 w_11843_25095.n63 w_11843_25095.t8 9.91222
R1063 w_11843_25095.n63 w_11843_25095.n60 54.8962
R1064 w_11843_25095.n60 w_11843_25095.n57 54.8962
R1065 w_11843_25095.n57 w_11843_25095.t6 9.91222
R1066 w_11843_25095.t6 w_11843_25095.n54 44.9844
R1067 w_11843_25095.n54 w_11843_25095.n51 54.8962
R1068 w_11843_25095.n51 w_11843_25095.t4 29.7357
R1069 w_11843_25095.n48 w_11843_25095.t4 25.161
R1070 w_11843_25095.n48 w_11843_25095.n45 54.8962
R1071 w_11843_25095.n45 w_11843_25095.t2 49.5591
R1072 w_11843_25095.n42 w_11843_25095.t2 5.33758
R1073 w_11843_25095.n42 w_11843_25095.n39 54.8962
R1074 w_11843_25095.n39 w_11843_25095.n36 54.8962
R1075 w_11843_25095.n36 w_11843_25095.t0 14.4869
R1076 w_11843_25095.t0 w_11843_25095.n204 40.4098
R1077 w_11843_25095.n204 w_11843_25095.n201 54.8962
R1078 w_11843_25095.n201 w_11843_25095.n197 57.9459
R1079 w_11843_25095.n35 w_11843_25095.n34 54.9658
R1080 w_11843_25095.n34 w_11843_25095.t3 12.313
R1081 w_11843_25095.n34 w_11843_25095.t1 12.313
R1082 w_11843_25095.n33 w_11843_25095.n32 54.9658
R1083 w_11843_25095.n32 w_11843_25095.t7 12.313
R1084 w_11843_25095.n32 w_11843_25095.t5 12.313
R1085 w_11843_25095.n31 w_11843_25095.n30 54.9658
R1086 w_11843_25095.n30 w_11843_25095.t11 12.313
R1087 w_11843_25095.n30 w_11843_25095.t9 12.313
R1088 w_6348_25095.t15 w_6348_25095.n0 12.313
R1089 w_6348_25095.n0 w_6348_25095.t13 12.313
R1090 w_6348_25095.n0 w_6348_25095.n208 54.9658
R1091 w_6348_25095.n2 w_6348_25095.n1 9.3005
R1092 w_6348_25095.n4 w_6348_25095.n3 9.3005
R1093 w_6348_25095.n6 w_6348_25095.n5 9.3005
R1094 w_6348_25095.n8 w_6348_25095.n7 9.3005
R1095 w_6348_25095.n10 w_6348_25095.n9 9.3005
R1096 w_6348_25095.n12 w_6348_25095.n11 9.3005
R1097 w_6348_25095.n14 w_6348_25095.n13 9.3005
R1098 w_6348_25095.n16 w_6348_25095.n15 9.3005
R1099 w_6348_25095.n18 w_6348_25095.n17 9.3005
R1100 w_6348_25095.n20 w_6348_25095.n19 9.3005
R1101 w_6348_25095.n22 w_6348_25095.n21 9.3005
R1102 w_6348_25095.n24 w_6348_25095.n23 9.3005
R1103 w_6348_25095.n26 w_6348_25095.n25 9.3005
R1104 w_6348_25095.n28 w_6348_25095.n27 9.3005
R1105 w_6348_25095.n208 w_6348_25095.n2 0.0173129
R1106 w_6348_25095.n2 w_6348_25095.n4 0.0531316
R1107 w_6348_25095.n4 w_6348_25095.n6 0.0531316
R1108 w_6348_25095.n6 w_6348_25095.n8 0.0531316
R1109 w_6348_25095.n8 w_6348_25095.n10 0.0531316
R1110 w_6348_25095.n10 w_6348_25095.n35 0.0216988
R1111 w_6348_25095.n35 w_6348_25095.n12 0.0319327
R1112 w_6348_25095.n12 w_6348_25095.n14 0.0531316
R1113 w_6348_25095.n14 w_6348_25095.n16 0.0531316
R1114 w_6348_25095.n16 w_6348_25095.n18 0.0531316
R1115 w_6348_25095.n18 w_6348_25095.n20 0.0531316
R1116 w_6348_25095.n20 w_6348_25095.n33 0.00707895
R1117 w_6348_25095.n33 w_6348_25095.n22 0.0465526
R1118 w_6348_25095.n22 w_6348_25095.n24 0.0531316
R1119 w_6348_25095.n24 w_6348_25095.n26 0.0531316
R1120 w_6348_25095.n26 w_6348_25095.n28 0.0531316
R1121 w_6348_25095.n28 w_6348_25095.n31 0.0450906
R1122 w_6348_25095.n31 w_6348_25095.n29 9.30854
R1123 w_6348_25095.n208 w_6348_25095.n207 9.38231
R1124 w_6348_25095.n36 w_6348_25095.n160 185
R1125 w_6348_25095.n37 w_6348_25095.n36 185
R1126 w_6348_25095.n38 w_6348_25095.n157 185
R1127 w_6348_25095.n39 w_6348_25095.n38 185
R1128 w_6348_25095.n40 w_6348_25095.n154 185
R1129 w_6348_25095.n41 w_6348_25095.n40 185
R1130 w_6348_25095.n42 w_6348_25095.n151 185
R1131 w_6348_25095.n43 w_6348_25095.n42 185
R1132 w_6348_25095.n44 w_6348_25095.n148 185
R1133 w_6348_25095.n45 w_6348_25095.n44 185
R1134 w_6348_25095.n46 w_6348_25095.n145 185
R1135 w_6348_25095.n47 w_6348_25095.n46 185
R1136 w_6348_25095.n48 w_6348_25095.n142 185
R1137 w_6348_25095.n49 w_6348_25095.n48 185
R1138 w_6348_25095.n50 w_6348_25095.n139 185
R1139 w_6348_25095.n51 w_6348_25095.n50 185
R1140 w_6348_25095.n52 w_6348_25095.n136 185
R1141 w_6348_25095.n53 w_6348_25095.n52 185
R1142 w_6348_25095.n54 w_6348_25095.n133 185
R1143 w_6348_25095.n55 w_6348_25095.n54 185
R1144 w_6348_25095.n56 w_6348_25095.n130 185
R1145 w_6348_25095.n57 w_6348_25095.n56 185
R1146 w_6348_25095.n58 w_6348_25095.n127 185
R1147 w_6348_25095.n59 w_6348_25095.n58 185
R1148 w_6348_25095.n60 w_6348_25095.n124 185
R1149 w_6348_25095.n61 w_6348_25095.n60 185
R1150 w_6348_25095.n62 w_6348_25095.n121 185
R1151 w_6348_25095.n63 w_6348_25095.n62 185
R1152 w_6348_25095.n64 w_6348_25095.n118 185
R1153 w_6348_25095.n65 w_6348_25095.n64 185
R1154 w_6348_25095.n66 w_6348_25095.n115 185
R1155 w_6348_25095.n67 w_6348_25095.n66 185
R1156 w_6348_25095.n68 w_6348_25095.n112 185
R1157 w_6348_25095.n69 w_6348_25095.n68 185
R1158 w_6348_25095.n207 w_6348_25095.n37 4.3525
R1159 w_6348_25095.n207 w_6348_25095.n39 14.0805
R1160 w_6348_25095.n1 w_6348_25095.n39 4.3525
R1161 w_6348_25095.n1 w_6348_25095.n41 14.0805
R1162 w_6348_25095.n3 w_6348_25095.n41 4.3525
R1163 w_6348_25095.n3 w_6348_25095.n43 14.0805
R1164 w_6348_25095.n5 w_6348_25095.n43 4.3525
R1165 w_6348_25095.n5 w_6348_25095.n45 14.0805
R1166 w_6348_25095.n7 w_6348_25095.n45 4.3525
R1167 w_6348_25095.n7 w_6348_25095.n47 14.0805
R1168 w_6348_25095.n9 w_6348_25095.n47 4.3525
R1169 w_6348_25095.n9 w_6348_25095.n49 14.0805
R1170 w_6348_25095.n11 w_6348_25095.n49 4.3525
R1171 w_6348_25095.n11 w_6348_25095.n51 14.0805
R1172 w_6348_25095.n13 w_6348_25095.n51 4.3525
R1173 w_6348_25095.n13 w_6348_25095.n53 14.0805
R1174 w_6348_25095.n15 w_6348_25095.n53 4.3525
R1175 w_6348_25095.n15 w_6348_25095.n55 14.0805
R1176 w_6348_25095.n17 w_6348_25095.n55 4.3525
R1177 w_6348_25095.n17 w_6348_25095.n57 14.0805
R1178 w_6348_25095.n19 w_6348_25095.n57 4.3525
R1179 w_6348_25095.n19 w_6348_25095.n59 14.0805
R1180 w_6348_25095.n21 w_6348_25095.n59 4.3525
R1181 w_6348_25095.n21 w_6348_25095.n61 14.0805
R1182 w_6348_25095.n23 w_6348_25095.n61 4.3525
R1183 w_6348_25095.n23 w_6348_25095.n63 14.0805
R1184 w_6348_25095.n25 w_6348_25095.n63 4.3525
R1185 w_6348_25095.n25 w_6348_25095.n65 14.0805
R1186 w_6348_25095.n27 w_6348_25095.n65 4.3525
R1187 w_6348_25095.n27 w_6348_25095.n67 14.0805
R1188 w_6348_25095.n29 w_6348_25095.n67 4.3525
R1189 w_6348_25095.n29 w_6348_25095.n69 14.0805
R1190 w_6348_25095.n70 w_6348_25095.n166 185
R1191 w_6348_25095.n71 w_6348_25095.n70 185
R1192 w_6348_25095.n72 w_6348_25095.n163 185
R1193 w_6348_25095.n73 w_6348_25095.n72 185
R1194 w_6348_25095.n73 w_6348_25095.n71 27.1064
R1195 w_6348_25095.n37 w_6348_25095.n73 21.9261
R1196 w_6348_25095.n74 w_6348_25095.n75 185
R1197 w_6348_25095.n75 w_6348_25095.n76 185
R1198 w_6348_25095.n79 w_6348_25095.n77 75.3262
R1199 w_6348_25095.n77 w_6348_25095.n78 185
R1200 w_6348_25095.n74 w_6348_25095.n79 54.8384
R1201 w_6348_25095.n80 w_6348_25095.n81 185
R1202 w_6348_25095.n84 w_6348_25095.n82 75.3262
R1203 w_6348_25095.n83 w_6348_25095.n82 185
R1204 w_6348_25095.n74 w_6348_25095.n84 54.8384
R1205 w_6348_25095.n86 w_6348_25095.n85 185
R1206 w_6348_25095.n89 w_6348_25095.n87 75.3262
R1207 w_6348_25095.n88 w_6348_25095.n87 185
R1208 w_6348_25095.n74 w_6348_25095.n89 54.8384
R1209 w_6348_25095.n91 w_6348_25095.n90 185
R1210 w_6348_25095.n94 w_6348_25095.n92 75.3262
R1211 w_6348_25095.n93 w_6348_25095.n92 185
R1212 w_6348_25095.n74 w_6348_25095.n94 54.8384
R1213 w_6348_25095.n96 w_6348_25095.n95 185
R1214 w_6348_25095.n99 w_6348_25095.n97 75.3262
R1215 w_6348_25095.n98 w_6348_25095.n97 185
R1216 w_6348_25095.n74 w_6348_25095.n99 54.8384
R1217 w_6348_25095.n101 w_6348_25095.n100 185
R1218 w_6348_25095.n104 w_6348_25095.n102 75.3262
R1219 w_6348_25095.n103 w_6348_25095.n102 185
R1220 w_6348_25095.n104 w_6348_25095.n74 54.8384
R1221 w_6348_25095.n106 w_6348_25095.n105 185
R1222 w_6348_25095.n71 w_6348_25095.n106 64.7534
R1223 w_6348_25095.n106 w_6348_25095.n103 27.1064
R1224 w_6348_25095.n103 w_6348_25095.n101 27.1064
R1225 w_6348_25095.n101 w_6348_25095.n98 27.1064
R1226 w_6348_25095.n98 w_6348_25095.n96 27.1064
R1227 w_6348_25095.n96 w_6348_25095.n93 27.1064
R1228 w_6348_25095.n93 w_6348_25095.n91 27.1064
R1229 w_6348_25095.n91 w_6348_25095.n88 27.1064
R1230 w_6348_25095.n88 w_6348_25095.n86 27.1064
R1231 w_6348_25095.n86 w_6348_25095.n83 27.1064
R1232 w_6348_25095.n83 w_6348_25095.n81 27.1064
R1233 w_6348_25095.n81 w_6348_25095.n78 27.1064
R1234 w_6348_25095.n78 w_6348_25095.n76 27.1064
R1235 w_6348_25095.n204 w_6348_25095.n107 185
R1236 w_6348_25095.n107 w_6348_25095.n108 185
R1237 w_6348_25095.n109 w_6348_25095.n110 185
R1238 w_6348_25095.n110 w_6348_25095.n111 185
R1239 w_6348_25095.n112 w_6348_25095.n113 185
R1240 w_6348_25095.n113 w_6348_25095.n114 185
R1241 w_6348_25095.n115 w_6348_25095.n116 185
R1242 w_6348_25095.n116 w_6348_25095.n117 185
R1243 w_6348_25095.n118 w_6348_25095.n119 185
R1244 w_6348_25095.n119 w_6348_25095.n120 185
R1245 w_6348_25095.n121 w_6348_25095.n122 185
R1246 w_6348_25095.n122 w_6348_25095.n123 185
R1247 w_6348_25095.n124 w_6348_25095.n125 185
R1248 w_6348_25095.n125 w_6348_25095.n126 185
R1249 w_6348_25095.n127 w_6348_25095.n128 185
R1250 w_6348_25095.n128 w_6348_25095.n129 185
R1251 w_6348_25095.n130 w_6348_25095.n131 185
R1252 w_6348_25095.n131 w_6348_25095.n132 185
R1253 w_6348_25095.n133 w_6348_25095.n134 185
R1254 w_6348_25095.n134 w_6348_25095.n135 185
R1255 w_6348_25095.n136 w_6348_25095.n137 185
R1256 w_6348_25095.n137 w_6348_25095.n138 185
R1257 w_6348_25095.n139 w_6348_25095.n140 185
R1258 w_6348_25095.n140 w_6348_25095.n141 185
R1259 w_6348_25095.n142 w_6348_25095.n143 185
R1260 w_6348_25095.n143 w_6348_25095.n144 185
R1261 w_6348_25095.n145 w_6348_25095.n146 185
R1262 w_6348_25095.n146 w_6348_25095.n147 185
R1263 w_6348_25095.n148 w_6348_25095.n149 185
R1264 w_6348_25095.n149 w_6348_25095.n150 185
R1265 w_6348_25095.n151 w_6348_25095.n152 185
R1266 w_6348_25095.n152 w_6348_25095.n153 185
R1267 w_6348_25095.n154 w_6348_25095.n155 185
R1268 w_6348_25095.n155 w_6348_25095.n156 185
R1269 w_6348_25095.n157 w_6348_25095.n158 185
R1270 w_6348_25095.n158 w_6348_25095.n159 185
R1271 w_6348_25095.n160 w_6348_25095.n161 185
R1272 w_6348_25095.n161 w_6348_25095.n162 185
R1273 w_6348_25095.n163 w_6348_25095.n164 185
R1274 w_6348_25095.n164 w_6348_25095.n165 185
R1275 w_6348_25095.n166 w_6348_25095.n167 185
R1276 w_6348_25095.n167 w_6348_25095.n168 185
R1277 w_6348_25095.n76 w_6348_25095.n168 64.7534
R1278 w_6348_25095.n168 w_6348_25095.n165 27.1064
R1279 w_6348_25095.n165 w_6348_25095.n162 27.1064
R1280 w_6348_25095.n162 w_6348_25095.n159 27.1064
R1281 w_6348_25095.n159 w_6348_25095.n156 27.1064
R1282 w_6348_25095.n156 w_6348_25095.n153 27.1064
R1283 w_6348_25095.n153 w_6348_25095.n150 27.1064
R1284 w_6348_25095.n150 w_6348_25095.n147 27.1064
R1285 w_6348_25095.n147 w_6348_25095.n144 27.1064
R1286 w_6348_25095.n144 w_6348_25095.n141 27.1064
R1287 w_6348_25095.n141 w_6348_25095.n138 27.1064
R1288 w_6348_25095.n138 w_6348_25095.n135 27.1064
R1289 w_6348_25095.n135 w_6348_25095.n132 27.1064
R1290 w_6348_25095.n129 w_6348_25095.n132 27.1064
R1291 w_6348_25095.n126 w_6348_25095.n129 27.1064
R1292 w_6348_25095.n123 w_6348_25095.n126 27.1064
R1293 w_6348_25095.n120 w_6348_25095.n123 27.1064
R1294 w_6348_25095.n117 w_6348_25095.n120 27.1064
R1295 w_6348_25095.n114 w_6348_25095.n117 27.1064
R1296 w_6348_25095.n111 w_6348_25095.n114 27.1064
R1297 w_6348_25095.n108 w_6348_25095.n111 27.1064
R1298 w_6348_25095.n169 w_6348_25095.n193 75.3262
R1299 w_6348_25095.n170 w_6348_25095.n169 185
R1300 w_6348_25095.n193 w_6348_25095.n198 54.8384
R1301 w_6348_25095.n172 w_6348_25095.n171 185
R1302 w_6348_25095.n173 w_6348_25095.n194 75.3262
R1303 w_6348_25095.n174 w_6348_25095.n173 185
R1304 w_6348_25095.n198 w_6348_25095.n194 54.8384
R1305 w_6348_25095.n176 w_6348_25095.n175 185
R1306 w_6348_25095.n177 w_6348_25095.n195 75.3262
R1307 w_6348_25095.n178 w_6348_25095.n177 185
R1308 w_6348_25095.n198 w_6348_25095.n195 54.8384
R1309 w_6348_25095.n180 w_6348_25095.n179 185
R1310 w_6348_25095.n196 w_6348_25095.n181 75.3262
R1311 w_6348_25095.n182 w_6348_25095.n181 185
R1312 w_6348_25095.n198 w_6348_25095.n196 54.8384
R1313 w_6348_25095.n184 w_6348_25095.n183 185
R1314 w_6348_25095.n197 w_6348_25095.n185 75.3262
R1315 w_6348_25095.n186 w_6348_25095.n185 185
R1316 w_6348_25095.n198 w_6348_25095.n197 54.8384
R1317 w_6348_25095.n188 w_6348_25095.n187 185
R1318 w_6348_25095.n198 w_6348_25095.n189 185
R1319 w_6348_25095.n190 w_6348_25095.n189 185
R1320 w_6348_25095.n199 w_6348_25095.n191 75.3262
R1321 w_6348_25095.n191 w_6348_25095.n192 185
R1322 w_6348_25095.n198 w_6348_25095.n199 54.8384
R1323 w_6348_25095.n200 w_6348_25095.n201 185
R1324 w_6348_25095.n170 w_6348_25095.n172 27.1064
R1325 w_6348_25095.n172 w_6348_25095.n174 27.1064
R1326 w_6348_25095.n174 w_6348_25095.n176 27.1064
R1327 w_6348_25095.n176 w_6348_25095.n178 27.1064
R1328 w_6348_25095.n178 w_6348_25095.n180 27.1064
R1329 w_6348_25095.n180 w_6348_25095.n182 27.1064
R1330 w_6348_25095.n182 w_6348_25095.n184 27.1064
R1331 w_6348_25095.n184 w_6348_25095.n186 27.1064
R1332 w_6348_25095.n186 w_6348_25095.n188 27.1064
R1333 w_6348_25095.n188 w_6348_25095.n190 27.1064
R1334 w_6348_25095.n190 w_6348_25095.n192 27.1064
R1335 w_6348_25095.n192 w_6348_25095.n201 27.1064
R1336 w_6348_25095.n201 w_6348_25095.n108 64.7534
R1337 w_6348_25095.n202 w_6348_25095.n109 185
R1338 w_6348_25095.n203 w_6348_25095.n202 185
R1339 w_6348_25095.n205 w_6348_25095.n204 185
R1340 w_6348_25095.n206 w_6348_25095.n205 185
R1341 w_6348_25095.n69 w_6348_25095.n203 26.504
R1342 w_6348_25095.n203 w_6348_25095.n206 27.1064
R1343 w_6348_25095.n206 w_6348_25095.n170 64.7534
R1344 w_6348_25095.n70 w_6348_25095.n72 254.119
R1345 w_6348_25095.n72 w_6348_25095.n36 254.119
R1346 w_6348_25095.n36 w_6348_25095.n38 254.119
R1347 w_6348_25095.n38 w_6348_25095.n40 254.119
R1348 w_6348_25095.n40 w_6348_25095.n42 254.119
R1349 w_6348_25095.n42 w_6348_25095.n44 254.119
R1350 w_6348_25095.n44 w_6348_25095.n46 254.119
R1351 w_6348_25095.n46 w_6348_25095.n48 254.119
R1352 w_6348_25095.n48 w_6348_25095.n50 254.119
R1353 w_6348_25095.n50 w_6348_25095.n52 254.119
R1354 w_6348_25095.n52 w_6348_25095.n54 254.119
R1355 w_6348_25095.n54 w_6348_25095.n56 254.119
R1356 w_6348_25095.n56 w_6348_25095.n58 254.119
R1357 w_6348_25095.n58 w_6348_25095.n60 254.119
R1358 w_6348_25095.n60 w_6348_25095.n62 254.119
R1359 w_6348_25095.n62 w_6348_25095.n64 254.119
R1360 w_6348_25095.n64 w_6348_25095.n66 254.119
R1361 w_6348_25095.n66 w_6348_25095.n68 254.119
R1362 w_6348_25095.n68 w_6348_25095.n202 254.119
R1363 w_6348_25095.n202 w_6348_25095.n205 254.119
R1364 w_6348_25095.n70 w_6348_25095.n105 607.059
R1365 w_6348_25095.n105 w_6348_25095.n104 75.3262
R1366 w_6348_25095.n102 w_6348_25095.n100 254.119
R1367 w_6348_25095.n100 w_6348_25095.n99 75.3262
R1368 w_6348_25095.n97 w_6348_25095.n95 254.119
R1369 w_6348_25095.n95 w_6348_25095.n94 75.3262
R1370 w_6348_25095.n92 w_6348_25095.n90 254.119
R1371 w_6348_25095.n90 w_6348_25095.n89 75.3262
R1372 w_6348_25095.n87 w_6348_25095.n85 254.119
R1373 w_6348_25095.n85 w_6348_25095.n84 75.3262
R1374 w_6348_25095.n82 w_6348_25095.n80 254.119
R1375 w_6348_25095.n79 w_6348_25095.n80 75.3262
R1376 w_6348_25095.n77 w_6348_25095.n75 254.119
R1377 w_6348_25095.n75 w_6348_25095.n167 607.059
R1378 w_6348_25095.n167 w_6348_25095.n164 254.119
R1379 w_6348_25095.n164 w_6348_25095.n161 254.119
R1380 w_6348_25095.n161 w_6348_25095.n158 254.119
R1381 w_6348_25095.n158 w_6348_25095.n155 254.119
R1382 w_6348_25095.n155 w_6348_25095.n152 254.119
R1383 w_6348_25095.n152 w_6348_25095.n149 254.119
R1384 w_6348_25095.n149 w_6348_25095.n146 254.119
R1385 w_6348_25095.n146 w_6348_25095.n143 254.119
R1386 w_6348_25095.n143 w_6348_25095.n140 254.119
R1387 w_6348_25095.n140 w_6348_25095.n137 254.119
R1388 w_6348_25095.n137 w_6348_25095.n134 254.119
R1389 w_6348_25095.n134 w_6348_25095.n131 254.119
R1390 w_6348_25095.n131 w_6348_25095.n128 254.119
R1391 w_6348_25095.n128 w_6348_25095.n125 254.119
R1392 w_6348_25095.n125 w_6348_25095.n122 254.119
R1393 w_6348_25095.n122 w_6348_25095.n119 254.119
R1394 w_6348_25095.n119 w_6348_25095.n116 254.119
R1395 w_6348_25095.n116 w_6348_25095.n113 254.119
R1396 w_6348_25095.n113 w_6348_25095.n110 254.119
R1397 w_6348_25095.n110 w_6348_25095.n107 254.119
R1398 w_6348_25095.n205 w_6348_25095.n169 607.059
R1399 w_6348_25095.n193 w_6348_25095.n171 75.3262
R1400 w_6348_25095.n171 w_6348_25095.n173 254.119
R1401 w_6348_25095.n194 w_6348_25095.n175 75.3262
R1402 w_6348_25095.n175 w_6348_25095.n177 254.119
R1403 w_6348_25095.n195 w_6348_25095.n179 75.3262
R1404 w_6348_25095.n179 w_6348_25095.n181 254.119
R1405 w_6348_25095.n196 w_6348_25095.n183 75.3262
R1406 w_6348_25095.n183 w_6348_25095.n185 254.119
R1407 w_6348_25095.n197 w_6348_25095.n187 75.3262
R1408 w_6348_25095.n187 w_6348_25095.n189 254.119
R1409 w_6348_25095.n189 w_6348_25095.n191 254.119
R1410 w_6348_25095.n199 w_6348_25095.n200 75.3262
R1411 w_6348_25095.n200 w_6348_25095.n107 607.059
R1412 w_6348_25095.n74 w_6348_25095.n166 57.9459
R1413 w_6348_25095.n166 w_6348_25095.n163 54.8962
R1414 w_6348_25095.n163 w_6348_25095.t14 40.4098
R1415 w_6348_25095.n160 w_6348_25095.t14 14.4869
R1416 w_6348_25095.n160 w_6348_25095.n157 54.8962
R1417 w_6348_25095.n157 w_6348_25095.n154 54.8962
R1418 w_6348_25095.n154 w_6348_25095.t12 5.33758
R1419 w_6348_25095.t12 w_6348_25095.n151 49.5591
R1420 w_6348_25095.n151 w_6348_25095.n148 54.8962
R1421 w_6348_25095.n148 w_6348_25095.t10 25.161
R1422 w_6348_25095.t10 w_6348_25095.n145 29.7357
R1423 w_6348_25095.n145 w_6348_25095.n142 54.8962
R1424 w_6348_25095.n142 w_6348_25095.t8 44.9844
R1425 w_6348_25095.n139 w_6348_25095.t8 9.91222
R1426 w_6348_25095.n139 w_6348_25095.n136 54.8962
R1427 w_6348_25095.n136 w_6348_25095.n133 54.8962
R1428 w_6348_25095.n133 w_6348_25095.t6 9.91222
R1429 w_6348_25095.t6 w_6348_25095.n130 44.9844
R1430 w_6348_25095.n130 w_6348_25095.n127 54.8962
R1431 w_6348_25095.n127 w_6348_25095.t4 29.7357
R1432 w_6348_25095.n124 w_6348_25095.t4 25.161
R1433 w_6348_25095.n124 w_6348_25095.n121 54.8962
R1434 w_6348_25095.n121 w_6348_25095.t2 49.5591
R1435 w_6348_25095.n118 w_6348_25095.t2 5.33758
R1436 w_6348_25095.n118 w_6348_25095.n115 54.8962
R1437 w_6348_25095.n115 w_6348_25095.n112 54.8962
R1438 w_6348_25095.n112 w_6348_25095.t0 14.4869
R1439 w_6348_25095.t0 w_6348_25095.n109 40.4098
R1440 w_6348_25095.n109 w_6348_25095.n204 54.8962
R1441 w_6348_25095.n204 w_6348_25095.n198 57.9459
R1442 w_6348_25095.n35 w_6348_25095.n34 54.9662
R1443 w_6348_25095.n34 w_6348_25095.t11 12.313
R1444 w_6348_25095.n34 w_6348_25095.t9 12.313
R1445 w_6348_25095.n33 w_6348_25095.n32 54.9662
R1446 w_6348_25095.n32 w_6348_25095.t7 12.313
R1447 w_6348_25095.n32 w_6348_25095.t5 12.313
R1448 w_6348_25095.n31 w_6348_25095.n30 54.9662
R1449 w_6348_25095.n30 w_6348_25095.t3 12.313
R1450 w_6348_25095.n30 w_6348_25095.t1 12.313
R1451 w_6290_22150.t1 w_6290_22150.n1 133.267
R1452 w_6290_22150.n1 w_6290_22150.n0 9.3005
R1453 w_6290_22150.n1 w_6290_22150.n2 9.3005
R1454 w_6290_22150.n1 w_6290_22150.n3 9.3005
R1455 w_6290_22150.n1 w_6290_22150.n4 9.3005
R1456 w_6290_22150.n6 w_6290_22150.n5 9.3005
R1457 w_6290_22150.n6 w_6290_22150.n7 9.3005
R1458 w_6290_22150.n6 w_6290_22150.n8 9.3005
R1459 w_6290_22150.n6 w_6290_22150.n92 9.3005
R1460 w_6290_22150.n1 w_6290_22150.n6 3.62047
R1461 w_6290_22150.n6 w_6290_22150.t3 133.267
R1462 w_6290_22150.n9 w_6290_22150.n36 585
R1463 w_6290_22150.n10 w_6290_22150.n9 585
R1464 w_6290_22150.n11 w_6290_22150.n33 585
R1465 w_6290_22150.n12 w_6290_22150.n11 585
R1466 w_6290_22150.n13 w_6290_22150.n30 585
R1467 w_6290_22150.n14 w_6290_22150.n13 585
R1468 w_6290_22150.n15 w_6290_22150.n27 585
R1469 w_6290_22150.n16 w_6290_22150.n15 585
R1470 w_6290_22150.n5 w_6290_22150.n16 0.6405
R1471 w_6290_22150.n5 w_6290_22150.n14 14.7205
R1472 w_6290_22150.n7 w_6290_22150.n14 0.6405
R1473 w_6290_22150.n7 w_6290_22150.n12 14.7205
R1474 w_6290_22150.n8 w_6290_22150.n12 0.6405
R1475 w_6290_22150.n8 w_6290_22150.n10 14.7205
R1476 w_6290_22150.n92 w_6290_22150.n10 0.6405
R1477 w_6290_22150.n17 w_6290_22150.n39 585
R1478 w_6290_22150.n18 w_6290_22150.n17 585
R1479 w_6290_22150.n92 w_6290_22150.n18 19.1252
R1480 w_6290_22150.n19 w_6290_22150.n20 585
R1481 w_6290_22150.n21 w_6290_22150.n20 585
R1482 w_6290_22150.n24 w_6290_22150.n22 153.763
R1483 w_6290_22150.n23 w_6290_22150.n22 585
R1484 w_6290_22150.n24 w_6290_22150.n19 215.619
R1485 w_6290_22150.n26 w_6290_22150.n25 585
R1486 w_6290_22150.n18 w_6290_22150.n26 72.6593
R1487 w_6290_22150.n26 w_6290_22150.n23 27.1064
R1488 w_6290_22150.n23 w_6290_22150.n21 27.1064
R1489 w_6290_22150.n27 w_6290_22150.n28 585
R1490 w_6290_22150.n29 w_6290_22150.n28 585
R1491 w_6290_22150.n30 w_6290_22150.n31 585
R1492 w_6290_22150.n32 w_6290_22150.n31 585
R1493 w_6290_22150.n33 w_6290_22150.n34 585
R1494 w_6290_22150.n35 w_6290_22150.n34 585
R1495 w_6290_22150.n36 w_6290_22150.n37 585
R1496 w_6290_22150.n38 w_6290_22150.n37 585
R1497 w_6290_22150.n39 w_6290_22150.n40 585
R1498 w_6290_22150.n41 w_6290_22150.n40 585
R1499 w_6290_22150.n29 w_6290_22150.n32 27.1064
R1500 w_6290_22150.n32 w_6290_22150.n35 27.1064
R1501 w_6290_22150.n35 w_6290_22150.n38 27.1064
R1502 w_6290_22150.n41 w_6290_22150.n38 27.1064
R1503 w_6290_22150.n21 w_6290_22150.n41 72.6593
R1504 w_6290_22150.n42 w_6290_22150.n46 153.763
R1505 w_6290_22150.n43 w_6290_22150.n42 585
R1506 w_6290_22150.n46 w_6290_22150.n47 215.619
R1507 w_6290_22150.n45 w_6290_22150.n44 585
R1508 w_6290_22150.n47 w_6290_22150.n90 585
R1509 w_6290_22150.n91 w_6290_22150.n90 585
R1510 w_6290_22150.n43 w_6290_22150.n45 27.1064
R1511 w_6290_22150.n45 w_6290_22150.n91 27.1064
R1512 w_6290_22150.n91 w_6290_22150.n29 72.6593
R1513 w_6290_22150.n16 w_6290_22150.n43 66.297
R1514 w_6290_22150.n46 w_6290_22150.n44 153.763
R1515 w_6290_22150.n44 w_6290_22150.n90 417.176
R1516 w_6290_22150.n42 w_6290_22150.n15 1118.26
R1517 w_6290_22150.n15 w_6290_22150.n13 417.176
R1518 w_6290_22150.n13 w_6290_22150.n11 417.176
R1519 w_6290_22150.n11 w_6290_22150.n9 417.176
R1520 w_6290_22150.n9 w_6290_22150.n17 417.176
R1521 w_6290_22150.n17 w_6290_22150.n25 1118.26
R1522 w_6290_22150.n25 w_6290_22150.n24 153.763
R1523 w_6290_22150.n22 w_6290_22150.n20 417.176
R1524 w_6290_22150.n90 w_6290_22150.n28 1118.26
R1525 w_6290_22150.n28 w_6290_22150.n31 417.176
R1526 w_6290_22150.n31 w_6290_22150.n34 417.176
R1527 w_6290_22150.n34 w_6290_22150.n37 417.176
R1528 w_6290_22150.n37 w_6290_22150.n40 417.176
R1529 w_6290_22150.n40 w_6290_22150.n20 1118.26
R1530 w_6290_22150.n47 w_6290_22150.n27 150.9
R1531 w_6290_22150.n27 w_6290_22150.n30 107.573
R1532 w_6290_22150.n30 w_6290_22150.t2 56.7747
R1533 w_6290_22150.n33 w_6290_22150.t2 50.7985
R1534 w_6290_22150.n33 w_6290_22150.n36 107.573
R1535 w_6290_22150.n36 w_6290_22150.n39 107.573
R1536 w_6290_22150.n39 w_6290_22150.n19 150.9
R1537 w_6290_22150.n47 w_6290_22150.n48 134425
R1538 w_6290_22150.n49 w_6290_22150.n50 585
R1539 w_6290_22150.n51 w_6290_22150.n50 585
R1540 w_6290_22150.n52 w_6290_22150.n53 585
R1541 w_6290_22150.n54 w_6290_22150.n53 585
R1542 w_6290_22150.n55 w_6290_22150.n56 585
R1543 w_6290_22150.n57 w_6290_22150.n56 585
R1544 w_6290_22150.n58 w_6290_22150.n59 585
R1545 w_6290_22150.n60 w_6290_22150.n59 585
R1546 w_6290_22150.n61 w_6290_22150.n62 585
R1547 w_6290_22150.n63 w_6290_22150.n62 585
R1548 w_6290_22150.n64 w_6290_22150.n65 585
R1549 w_6290_22150.n66 w_6290_22150.n65 585
R1550 w_6290_22150.n69 w_6290_22150.n67 153.763
R1551 w_6290_22150.n68 w_6290_22150.n67 585
R1552 w_6290_22150.n69 w_6290_22150.n64 215.619
R1553 w_6290_22150.n71 w_6290_22150.n70 585
R1554 w_6290_22150.n72 w_6290_22150.n61 585
R1555 w_6290_22150.n73 w_6290_22150.n72 585
R1556 w_6290_22150.n74 w_6290_22150.n58 585
R1557 w_6290_22150.n75 w_6290_22150.n74 585
R1558 w_6290_22150.n76 w_6290_22150.n55 585
R1559 w_6290_22150.n77 w_6290_22150.n76 585
R1560 w_6290_22150.n78 w_6290_22150.n52 585
R1561 w_6290_22150.n79 w_6290_22150.n78 585
R1562 w_6290_22150.n80 w_6290_22150.n49 585
R1563 w_6290_22150.n81 w_6290_22150.n80 585
R1564 w_6290_22150.n86 w_6290_22150.n82 585
R1565 w_6290_22150.n83 w_6290_22150.n82 585
R1566 w_6290_22150.n84 w_6290_22150.n87 153.763
R1567 w_6290_22150.n85 w_6290_22150.n84 585
R1568 w_6290_22150.n87 w_6290_22150.n86 215.619
R1569 w_6290_22150.n89 w_6290_22150.n88 585
R1570 w_6290_22150.n86 w_6290_22150.n49 150.9
R1571 w_6290_22150.n49 w_6290_22150.n52 107.573
R1572 w_6290_22150.n52 w_6290_22150.n55 107.573
R1573 w_6290_22150.n55 w_6290_22150.t0 50.7985
R1574 w_6290_22150.t0 w_6290_22150.n58 56.7747
R1575 w_6290_22150.n58 w_6290_22150.n61 107.573
R1576 w_6290_22150.n61 w_6290_22150.n64 150.9
R1577 w_6290_22150.n64 w_6290_22150.n48 7513.18
R1578 w_6290_22150.n19 w_6290_22150.n48 2962.53
R1579 w_6290_22150.n48 w_6290_22150.n86 2963.47
R1580 w_6290_22150.n83 w_6290_22150.n85 27.1064
R1581 w_6290_22150.n85 w_6290_22150.n89 27.1064
R1582 w_6290_22150.n81 w_6290_22150.n83 72.6593
R1583 w_6290_22150.n2 w_6290_22150.n81 19.1252
R1584 w_6290_22150.n2 w_6290_22150.n79 0.6405
R1585 w_6290_22150.n79 w_6290_22150.n3 14.7205
R1586 w_6290_22150.n3 w_6290_22150.n77 0.6405
R1587 w_6290_22150.n77 w_6290_22150.n4 14.7205
R1588 w_6290_22150.n4 w_6290_22150.n75 0.6405
R1589 w_6290_22150.n75 w_6290_22150.n0 14.7205
R1590 w_6290_22150.n0 w_6290_22150.n73 0.6405
R1591 w_6290_22150.n73 w_6290_22150.n71 66.297
R1592 w_6290_22150.n71 w_6290_22150.n68 27.1064
R1593 w_6290_22150.n68 w_6290_22150.n66 27.1064
R1594 w_6290_22150.n89 w_6290_22150.n51 72.6593
R1595 w_6290_22150.n51 w_6290_22150.n54 27.1064
R1596 w_6290_22150.n54 w_6290_22150.n57 27.1064
R1597 w_6290_22150.n60 w_6290_22150.n57 27.1064
R1598 w_6290_22150.n63 w_6290_22150.n60 27.1064
R1599 w_6290_22150.n66 w_6290_22150.n63 72.6593
R1600 w_6290_22150.n82 w_6290_22150.n84 417.176
R1601 w_6290_22150.n87 w_6290_22150.n88 153.763
R1602 w_6290_22150.n82 w_6290_22150.n80 1118.26
R1603 w_6290_22150.n80 w_6290_22150.n78 417.176
R1604 w_6290_22150.n78 w_6290_22150.n76 417.176
R1605 w_6290_22150.n76 w_6290_22150.n74 417.176
R1606 w_6290_22150.n74 w_6290_22150.n72 417.176
R1607 w_6290_22150.n72 w_6290_22150.n70 1118.26
R1608 w_6290_22150.n70 w_6290_22150.n69 153.763
R1609 w_6290_22150.n67 w_6290_22150.n65 417.176
R1610 w_6290_22150.n88 w_6290_22150.n50 1118.26
R1611 w_6290_22150.n50 w_6290_22150.n53 417.176
R1612 w_6290_22150.n53 w_6290_22150.n56 417.176
R1613 w_6290_22150.n56 w_6290_22150.n59 417.176
R1614 w_6290_22150.n59 w_6290_22150.n62 417.176
R1615 w_6290_22150.n62 w_6290_22150.n65 1118.26
C0 c1_8428_29658# 0 3.33129f
C1 a_12566_23415# 0 1.00679f
C2 a_6525_23427# 0 1.00679f
C3 a_11994_25339# 0 0.91971f
C4 a_6497_25339# 0 0.91971f
C5 w_6348_25095.t15 0 0.0417f
C6 w_6348_25095.n0 0 0.08648f
C7 w_6348_25095.n2 0 0.01693f
C8 w_6348_25095.n4 0 0.02567f
C9 w_6348_25095.n6 0 0.02567f
C10 w_6348_25095.n8 0 0.02567f
C11 w_6348_25095.n10 0 0.018f
C12 w_6348_25095.n12 0 0.0205f
C13 w_6348_25095.n14 0 0.02567f
C14 w_6348_25095.n16 0 0.02567f
C15 w_6348_25095.n18 0 0.02567f
C16 w_6348_25095.n20 0 0.01444f
C17 w_6348_25095.n22 0 0.02406f
C18 w_6348_25095.n24 0 0.02567f
C19 w_6348_25095.n26 0 0.02567f
C20 w_6348_25095.n28 0 0.02371f
C21 w_6348_25095.n30 0 0.08648f
C22 w_6348_25095.t1 0 0.0417f
C23 w_6348_25095.t3 0 0.0417f
C24 w_6348_25095.n31 0 0.69819f
C25 w_6348_25095.n32 0 0.08648f
C26 w_6348_25095.t5 0 0.0417f
C27 w_6348_25095.t7 0 0.0417f
C28 w_6348_25095.n33 0 0.14841f
C29 w_6348_25095.n34 0 0.08648f
C30 w_6348_25095.t9 0 0.0417f
C31 w_6348_25095.t11 0 0.0417f
C32 w_6348_25095.n35 0 0.14841f
C33 w_6348_25095.n74 0 0.30133f
C34 w_6348_25095.n109 0 0.16235f
C35 w_6348_25095.n112 0 0.11819f
C36 w_6348_25095.n115 0 0.18703f
C37 w_6348_25095.n118 0 0.10261f
C38 w_6348_25095.n121 0 0.17794f
C39 w_6348_25095.n124 0 0.13638f
C40 w_6348_25095.n127 0 0.14417f
C41 w_6348_25095.n130 0 0.17015f
C42 w_6348_25095.n133 0 0.1104f
C43 w_6348_25095.n136 0 0.18703f
C44 w_6348_25095.n139 0 0.1104f
C45 w_6348_25095.n142 0 0.17015f
C46 w_6348_25095.n145 0 0.14417f
C47 w_6348_25095.n148 0 0.13638f
C48 w_6348_25095.n151 0 0.17794f
C49 w_6348_25095.n154 0 0.10261f
C50 w_6348_25095.n157 0 0.18703f
C51 w_6348_25095.n160 0 0.11819f
C52 w_6348_25095.n163 0 0.16235f
C53 w_6348_25095.n166 0 0.19223f
C54 w_6348_25095.n198 0 0.30133f
C55 w_6348_25095.n204 0 0.19223f
C56 w_6348_25095.t0 0 0.09352f
C57 w_6348_25095.t2 0 0.09352f
C58 w_6348_25095.t4 0 0.09352f
C59 w_6348_25095.t6 0 0.09352f
C60 w_6348_25095.t8 0 0.09352f
C61 w_6348_25095.t10 0 0.09352f
C62 w_6348_25095.t12 0 0.09352f
C63 w_6348_25095.t14 0 0.09352f
C64 w_6348_25095.n208 0 0.15676f
C65 w_6348_25095.t13 0 0.0417f
C66 w_11843_25095.t15 0 0.0417f
C67 w_11843_25095.n0 0 0.08648f
C68 w_11843_25095.n2 0 0.01693f
C69 w_11843_25095.n4 0 0.02567f
C70 w_11843_25095.n6 0 0.02567f
C71 w_11843_25095.n8 0 0.02567f
C72 w_11843_25095.n10 0 0.018f
C73 w_11843_25095.n12 0 0.0205f
C74 w_11843_25095.n14 0 0.02567f
C75 w_11843_25095.n16 0 0.02567f
C76 w_11843_25095.n18 0 0.02567f
C77 w_11843_25095.n20 0 0.01444f
C78 w_11843_25095.n22 0 0.02406f
C79 w_11843_25095.n24 0 0.02567f
C80 w_11843_25095.n26 0 0.02567f
C81 w_11843_25095.n28 0 0.02371f
C82 w_11843_25095.n30 0 0.08648f
C83 w_11843_25095.t9 0 0.0417f
C84 w_11843_25095.t11 0 0.0417f
C85 w_11843_25095.n31 0 0.14841f
C86 w_11843_25095.n32 0 0.08648f
C87 w_11843_25095.t5 0 0.0417f
C88 w_11843_25095.t7 0 0.0417f
C89 w_11843_25095.n33 0 0.14841f
C90 w_11843_25095.n34 0 0.08648f
C91 w_11843_25095.t1 0 0.0417f
C92 w_11843_25095.t3 0 0.0417f
C93 w_11843_25095.n35 0 0.6982f
C94 w_11843_25095.n36 0 0.11819f
C95 w_11843_25095.n39 0 0.18703f
C96 w_11843_25095.n42 0 0.10261f
C97 w_11843_25095.n45 0 0.17794f
C98 w_11843_25095.n48 0 0.13638f
C99 w_11843_25095.n51 0 0.14417f
C100 w_11843_25095.n54 0 0.17015f
C101 w_11843_25095.n57 0 0.1104f
C102 w_11843_25095.n60 0 0.18703f
C103 w_11843_25095.n63 0 0.1104f
C104 w_11843_25095.n66 0 0.17015f
C105 w_11843_25095.n69 0 0.14417f
C106 w_11843_25095.n72 0 0.13638f
C107 w_11843_25095.n75 0 0.17794f
C108 w_11843_25095.n78 0 0.10261f
C109 w_11843_25095.n81 0 0.18703f
C110 w_11843_25095.n84 0 0.11819f
C111 w_11843_25095.n87 0 0.16236f
C112 w_11843_25095.n90 0 0.19223f
C113 w_11843_25095.n93 0 0.30133f
C114 w_11843_25095.n197 0 0.30133f
C115 w_11843_25095.n201 0 0.19223f
C116 w_11843_25095.n204 0 0.16236f
C117 w_11843_25095.t0 0 0.09352f
C118 w_11843_25095.t2 0 0.09352f
C119 w_11843_25095.t4 0 0.09352f
C120 w_11843_25095.t6 0 0.09352f
C121 w_11843_25095.t8 0 0.09352f
C122 w_11843_25095.t10 0 0.09352f
C123 w_11843_25095.t12 0 0.09352f
C124 w_11843_25095.t14 0 0.09352f
C125 w_11843_25095.n208 0 0.15676f
C126 w_11843_25095.t13 0 0.0417f
C127 a_6537_25279.t8 0 0.05927f
C128 a_6537_25279.n0 0 0.02675f
C129 a_6537_25279.n1 0 0.02135f
C130 a_6537_25279.n2 0 0.02346f
C131 a_6537_25279.n3 0 0.01687f
C132 a_6537_25279.n5 0 0.05229f
C133 a_6537_25279.n7 0 0.01687f
C134 a_6537_25279.n9 0 0.01687f
C135 a_6537_25279.n11 0 0.01687f
C136 a_6537_25279.n13 0 0.01687f
C137 a_6537_25279.n15 0 0.01687f
C138 a_6537_25279.n17 0 0.01687f
C139 a_6537_25279.n19 0 0.01687f
C140 a_6537_25279.n20 0 0.01687f
C141 a_6537_25279.n21 0 0.01008f
C142 a_6537_25279.n22 0 0.01008f
C143 a_6537_25279.n24 0 0.01008f
C144 a_6537_25279.n26 0 0.01008f
C145 a_6537_25279.n28 0 0.01008f
C146 a_6537_25279.n30 0 0.01008f
C147 a_6537_25279.n32 0 0.01008f
C148 a_6537_25279.n34 0 0.01008f
C149 a_6537_25279.n36 0 0.01008f
C150 a_6537_25279.n43 0 0.14828f
C151 a_6537_25279.t6 0 0.04943f
C152 a_6537_25279.n44 0 0.01687f
C153 a_6537_25279.n45 0 2.11221f
C154 a_6537_25279.n46 0 0.02675f
C155 a_6537_25279.n47 0 0.02135f
C156 a_6537_25279.n48 0 0.02346f
C157 a_6537_25279.n49 0 0.01687f
C158 a_6537_25279.n51 0 0.05229f
C159 a_6537_25279.n53 0 0.01687f
C160 a_6537_25279.n55 0 0.01687f
C161 a_6537_25279.n57 0 0.01687f
C162 a_6537_25279.n59 0 0.01687f
C163 a_6537_25279.n61 0 0.01687f
C164 a_6537_25279.n63 0 0.01687f
C165 a_6537_25279.n65 0 0.01687f
C166 a_6537_25279.n66 0 0.01687f
C167 a_6537_25279.n67 0 0.01008f
C168 a_6537_25279.n68 0 0.01008f
C169 a_6537_25279.n70 0 0.01008f
C170 a_6537_25279.n72 0 0.01008f
C171 a_6537_25279.n74 0 0.01008f
C172 a_6537_25279.n76 0 0.01008f
C173 a_6537_25279.n78 0 0.01008f
C174 a_6537_25279.n80 0 0.01008f
C175 a_6537_25279.n82 0 0.01008f
C176 a_6537_25279.n89 0 0.16476f
C177 a_6537_25279.t0 0 0.08238f
C178 a_6537_25279.t2 0 0.08238f
C179 a_6537_25279.n90 0 0.01687f
C180 a_6537_25279.n91 0 0.13117f
C181 a_6537_25279.n92 0 0.02675f
C182 a_6537_25279.n93 0 0.02135f
C183 a_6537_25279.n94 0 0.02346f
C184 a_6537_25279.n95 0 0.01687f
C185 a_6537_25279.n97 0 0.05229f
C186 a_6537_25279.n99 0 0.01687f
C187 a_6537_25279.n101 0 0.01687f
C188 a_6537_25279.n103 0 0.01687f
C189 a_6537_25279.n105 0 0.01687f
C190 a_6537_25279.n107 0 0.01687f
C191 a_6537_25279.n109 0 0.01687f
C192 a_6537_25279.n111 0 0.01687f
C193 a_6537_25279.n112 0 0.01687f
C194 a_6537_25279.n113 0 0.01008f
C195 a_6537_25279.n114 0 0.01008f
C196 a_6537_25279.n116 0 0.01008f
C197 a_6537_25279.n118 0 0.01008f
C198 a_6537_25279.n120 0 0.01008f
C199 a_6537_25279.n122 0 0.01008f
C200 a_6537_25279.n124 0 0.01008f
C201 a_6537_25279.n126 0 0.01008f
C202 a_6537_25279.n128 0 0.01008f
C203 a_6537_25279.n135 0 0.16476f
C204 a_6537_25279.t1 0 0.08238f
C205 a_6537_25279.t3 0 0.08238f
C206 a_6537_25279.n136 0 0.01687f
C207 a_6537_25279.n137 0 0.13475f
C208 a_6537_25279.n138 0 0.02675f
C209 a_6537_25279.n139 0 0.02135f
C210 a_6537_25279.n140 0 0.02346f
C211 a_6537_25279.n141 0 0.01687f
C212 a_6537_25279.n143 0 0.05229f
C213 a_6537_25279.n145 0 0.01687f
C214 a_6537_25279.n147 0 0.01687f
C215 a_6537_25279.n149 0 0.01687f
C216 a_6537_25279.n151 0 0.01687f
C217 a_6537_25279.n153 0 0.01687f
C218 a_6537_25279.n155 0 0.01687f
C219 a_6537_25279.n157 0 0.01687f
C220 a_6537_25279.n158 0 0.01687f
C221 a_6537_25279.n159 0 0.01008f
C222 a_6537_25279.n160 0 0.01008f
C223 a_6537_25279.n162 0 0.01008f
C224 a_6537_25279.n164 0 0.01008f
C225 a_6537_25279.n166 0 0.01008f
C226 a_6537_25279.n168 0 0.01008f
C227 a_6537_25279.n170 0 0.01008f
C228 a_6537_25279.n172 0 0.01008f
C229 a_6537_25279.n174 0 0.01008f
C230 a_6537_25279.n181 0 0.16476f
C231 a_6537_25279.t5 0 0.08238f
C232 a_6537_25279.t7 0 0.08238f
C233 a_6537_25279.n182 0 0.01687f
C234 a_6537_25279.n183 0 0.15537f
C235 a_6537_25279.n184 0 0.02922f
C236 a_6537_25279.n185 0 0.01687f
C237 a_6537_25279.n187 0 0.05229f
C238 a_6537_25279.n189 0 0.01687f
C239 a_6537_25279.n191 0 0.01687f
C240 a_6537_25279.n193 0 0.01687f
C241 a_6537_25279.n195 0 0.01687f
C242 a_6537_25279.n197 0 0.01687f
C243 a_6537_25279.n199 0 0.01687f
C244 a_6537_25279.n201 0 0.01687f
C245 a_6537_25279.n202 0 0.01687f
C246 a_6537_25279.n203 0 0.01687f
C247 a_6537_25279.n204 0 0.01008f
C248 a_6537_25279.n205 0 0.01008f
C249 a_6537_25279.n207 0 0.01008f
C250 a_6537_25279.n209 0 0.01008f
C251 a_6537_25279.n211 0 0.01008f
C252 a_6537_25279.n213 0 0.01008f
C253 a_6537_25279.n215 0 0.01008f
C254 a_6537_25279.n217 0 0.01008f
C255 a_6537_25279.n219 0 0.01008f
C256 a_6537_25279.n226 0 0.14828f
C257 a_6537_25279.t4 0 0.04943f
C258 a_6537_25279.n227 0 0.02107f
C259 a_6537_25279.n228 0 0.07923f
C260 a_12100_25279.t0 0 0.06087f
C261 a_12100_25279.n0 0 0.02675f
C262 a_12100_25279.n1 0 0.07923f
C263 a_12100_25279.n2 0 0.01687f
C264 a_12100_25279.n3 0 0.01687f
C265 a_12100_25279.n5 0 0.01687f
C266 a_12100_25279.n7 0 0.01687f
C267 a_12100_25279.n9 0 0.01687f
C268 a_12100_25279.n11 0 0.01687f
C269 a_12100_25279.n13 0 0.01687f
C270 a_12100_25279.n15 0 0.01687f
C271 a_12100_25279.n17 0 0.01687f
C272 a_12100_25279.n19 0 0.05229f
C273 a_12100_25279.n20 0 0.01687f
C274 a_12100_25279.n21 0 0.01008f
C275 a_12100_25279.n22 0 0.01008f
C276 a_12100_25279.n24 0 0.01008f
C277 a_12100_25279.n26 0 0.01008f
C278 a_12100_25279.n28 0 0.01008f
C279 a_12100_25279.n30 0 0.01008f
C280 a_12100_25279.n32 0 0.01008f
C281 a_12100_25279.n34 0 0.01008f
C282 a_12100_25279.n36 0 0.01008f
C283 a_12100_25279.n43 0 0.14828f
C284 a_12100_25279.t6 0 0.04943f
C285 a_12100_25279.n44 0 0.02346f
C286 a_12100_25279.n45 0 0.02922f
C287 a_12100_25279.n46 0 0.02107f
C288 a_12100_25279.n47 0 0.02135f
C289 a_12100_25279.n48 0 0.01687f
C290 a_12100_25279.n49 0 0.01687f
C291 a_12100_25279.n51 0 0.01687f
C292 a_12100_25279.n53 0 0.01687f
C293 a_12100_25279.n55 0 0.01687f
C294 a_12100_25279.n57 0 0.01687f
C295 a_12100_25279.n59 0 0.01687f
C296 a_12100_25279.n61 0 0.01687f
C297 a_12100_25279.n63 0 0.01687f
C298 a_12100_25279.n65 0 0.05229f
C299 a_12100_25279.n66 0 0.01687f
C300 a_12100_25279.n67 0 0.01008f
C301 a_12100_25279.n68 0 0.01008f
C302 a_12100_25279.n70 0 0.01008f
C303 a_12100_25279.n72 0 0.01008f
C304 a_12100_25279.n74 0 0.01008f
C305 a_12100_25279.n76 0 0.01008f
C306 a_12100_25279.n78 0 0.01008f
C307 a_12100_25279.n80 0 0.01008f
C308 a_12100_25279.n82 0 0.01008f
C309 a_12100_25279.n89 0 0.16476f
C310 a_12100_25279.t8 0 0.08238f
C311 a_12100_25279.t5 0 0.08238f
C312 a_12100_25279.n90 0 0.15537f
C313 a_12100_25279.n91 0 0.02922f
C314 a_12100_25279.n92 0 0.02107f
C315 a_12100_25279.n93 0 0.02135f
C316 a_12100_25279.n94 0 0.01687f
C317 a_12100_25279.n95 0 0.01687f
C318 a_12100_25279.n97 0 0.01687f
C319 a_12100_25279.n99 0 0.01687f
C320 a_12100_25279.n101 0 0.01687f
C321 a_12100_25279.n103 0 0.01687f
C322 a_12100_25279.n105 0 0.01687f
C323 a_12100_25279.n107 0 0.01687f
C324 a_12100_25279.n109 0 0.01687f
C325 a_12100_25279.n111 0 0.05229f
C326 a_12100_25279.n112 0 0.01687f
C327 a_12100_25279.n113 0 0.01008f
C328 a_12100_25279.n114 0 0.01008f
C329 a_12100_25279.n116 0 0.01008f
C330 a_12100_25279.n118 0 0.01008f
C331 a_12100_25279.n120 0 0.01008f
C332 a_12100_25279.n122 0 0.01008f
C333 a_12100_25279.n124 0 0.01008f
C334 a_12100_25279.n126 0 0.01008f
C335 a_12100_25279.n128 0 0.01008f
C336 a_12100_25279.n135 0 0.16476f
C337 a_12100_25279.t2 0 0.08238f
C338 a_12100_25279.t4 0 0.08238f
C339 a_12100_25279.n136 0 0.13475f
C340 a_12100_25279.n137 0 0.02922f
C341 a_12100_25279.n138 0 0.02107f
C342 a_12100_25279.n139 0 0.02135f
C343 a_12100_25279.n140 0 0.01687f
C344 a_12100_25279.n141 0 0.01687f
C345 a_12100_25279.n143 0 0.01687f
C346 a_12100_25279.n145 0 0.01687f
C347 a_12100_25279.n147 0 0.01687f
C348 a_12100_25279.n149 0 0.01687f
C349 a_12100_25279.n151 0 0.01687f
C350 a_12100_25279.n153 0 0.01687f
C351 a_12100_25279.n155 0 0.01687f
C352 a_12100_25279.n157 0 0.05229f
C353 a_12100_25279.n158 0 0.01687f
C354 a_12100_25279.n159 0 0.01008f
C355 a_12100_25279.n160 0 0.01008f
C356 a_12100_25279.n162 0 0.01008f
C357 a_12100_25279.n164 0 0.01008f
C358 a_12100_25279.n166 0 0.01008f
C359 a_12100_25279.n168 0 0.01008f
C360 a_12100_25279.n170 0 0.01008f
C361 a_12100_25279.n172 0 0.01008f
C362 a_12100_25279.n174 0 0.01008f
C363 a_12100_25279.n181 0 0.16476f
C364 a_12100_25279.t7 0 0.08238f
C365 a_12100_25279.t3 0 0.08238f
C366 a_12100_25279.n182 0 0.13117f
C367 a_12100_25279.n183 0 0.02922f
C368 a_12100_25279.n184 0 0.02107f
C369 a_12100_25279.n185 0 0.02135f
C370 a_12100_25279.n186 0 0.01687f
C371 a_12100_25279.n187 0 0.01687f
C372 a_12100_25279.n189 0 0.01687f
C373 a_12100_25279.n191 0 0.01687f
C374 a_12100_25279.n193 0 0.01687f
C375 a_12100_25279.n195 0 0.01687f
C376 a_12100_25279.n197 0 0.01687f
C377 a_12100_25279.n199 0 0.01687f
C378 a_12100_25279.n201 0 0.01687f
C379 a_12100_25279.n203 0 0.05229f
C380 a_12100_25279.n204 0 0.01687f
C381 a_12100_25279.n205 0 0.01008f
C382 a_12100_25279.n206 0 0.01008f
C383 a_12100_25279.n208 0 0.01008f
C384 a_12100_25279.n210 0 0.01008f
C385 a_12100_25279.n212 0 0.01008f
C386 a_12100_25279.n214 0 0.01008f
C387 a_12100_25279.n216 0 0.01008f
C388 a_12100_25279.n218 0 0.01008f
C389 a_12100_25279.n220 0 0.01008f
C390 a_12100_25279.n227 0 0.14828f
C391 a_12100_25279.t1 0 0.04943f
C392 a_12100_25279.n228 0 2.11061f
C393 m3_8388_29618.n0 0 21.1456f
C394 m3_8388_29618.t0 0 68.4968f
.ends
